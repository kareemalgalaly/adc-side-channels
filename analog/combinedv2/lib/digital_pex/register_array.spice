* NGSPICE file created from reg_array.ext - technology: sky130A
* %s/\v<sky130_fd_sc_hs__([a-zA-Z0-9]+_\d+)>/ra_\1/g

.subckt ra_mux2i_1 VNB VPB VPWR VGND S A1 A0 Y a_225_74# a_399_368#
+ a_223_368# a_114_74# a_426_74#
X0 a_114_74# S VPWR VPB sky130_fd_pr__pfet_01v8 ad=0.231 pd=2.23 as=0.2394 ps=2.25 w=0.84 l=0.15
X1 a_399_368# A1 Y VPB sky130_fd_pr__pfet_01v8 ad=0.3192 pd=2.81 as=0.168 ps=1.42 w=1.12 l=0.15
X2 a_114_74# S VGND VNB sky130_fd_pr__nfet_01v8_lvt ad=0.15675 pd=1.67 as=0.15675 ps=1.67 w=0.55 l=0.15
X3 Y A0 a_223_368# VPB sky130_fd_pr__pfet_01v8 ad=0.168 pd=1.42 as=0.3136 ps=2.8 w=1.12 l=0.15
X4 a_426_74# a_114_74# VGND VNB sky130_fd_pr__nfet_01v8_lvt ad=0.0888 pd=0.98 as=0.1554 ps=1.16 w=0.74 l=0.15
X5 VGND S a_225_74# VNB sky130_fd_pr__nfet_01v8_lvt ad=0.1554 pd=1.16 as=0.2109 ps=2.05 w=0.74 l=0.15
X6 a_225_74# A1 Y VNB sky130_fd_pr__nfet_01v8_lvt ad=0.2109 pd=2.05 as=0.26085 ps=1.445 w=0.74 l=0.15
X7 a_399_368# a_114_74# VPWR VPB sky130_fd_pr__pfet_01v8 ad=0.308 pd=2.79 as=0.168 ps=1.42 w=1.12 l=0.15
X8 Y A0 a_426_74# VNB sky130_fd_pr__nfet_01v8_lvt ad=0.26085 pd=1.445 as=0.0888 ps=0.98 w=0.74 l=0.15
X9 VPWR S a_223_368# VPB sky130_fd_pr__pfet_01v8 ad=0.168 pd=1.42 as=0.3136 ps=2.8 w=1.12 l=0.15
C0 a_114_74# a_399_368# 0.00862f
C1 a_426_74# VPWR 0
C2 VPB A0 0.0495f
C3 a_426_74# a_223_368# 0
C4 A0 VPWR 0.00717f
C5 S Y 0
C6 A0 a_223_368# 0.04034f
C7 a_225_74# a_114_74# 0.15743f
C8 a_399_368# A1 0.0459f
C9 a_225_74# A1 0.04251f
C10 S VGND 0.0572f
C11 a_225_74# a_399_368# 0.00207f
C12 Y VGND 0.01311f
C13 A0 a_114_74# 0.06674f
C14 VPB S 0.12445f
C15 S VPWR 0.0624f
C16 VPB Y 0.00714f
C17 A0 A1 0.04289f
C18 S a_223_368# 0.02402f
C19 A0 a_399_368# 0.01325f
C20 VPWR Y 0.00926f
C21 a_223_368# Y 0.06387f
C22 a_426_74# a_225_74# 0.01024f
C23 VPB VGND 0.01026f
C24 A0 a_225_74# 0.01495f
C25 VPWR VGND 0.0608f
C26 a_223_368# VGND 0.00384f
C27 S a_114_74# 0.17504f
C28 a_114_74# Y 0.003f
C29 VPB VPWR 0.12214f
C30 VPB a_223_368# 0.02404f
C31 S a_399_368# 0
C32 A1 Y 0.05254f
C33 a_223_368# VPWR 0.13664f
C34 a_114_74# VGND 0.09604f
C35 a_399_368# Y 0.09939f
C36 S a_225_74# 0.02611f
C37 A1 VGND 0.00999f
C38 a_225_74# Y 0.1278f
C39 a_399_368# VGND 0.00335f
C40 VPB a_114_74# 0.06051f
C41 a_114_74# VPWR 0.12826f
C42 a_223_368# a_114_74# 0.15828f
C43 a_225_74# VGND 0.30409f
C44 VPB A1 0.03993f
C45 a_426_74# Y 0.00108f
C46 S A0 0
C47 VPB a_399_368# 0.02949f
C48 A1 VPWR 0.00675f
C49 A0 Y 0.07873f
C50 a_399_368# VPWR 0.25392f
C51 a_223_368# a_399_368# 0.10003f
C52 a_426_74# VGND 0
C53 VPB a_225_74# 0.00114f
C54 a_225_74# VPWR 0.00293f
C55 A0 VGND 0.00906f
C56 a_223_368# a_225_74# 0.00764f
C57 VGND VNB 0.51358f
C58 Y VNB 0.02522f
C59 VPWR VNB 0.40799f
C60 A1 VNB 0.14178f
C61 A0 VNB 0.10078f
C62 S VNB 0.31745f
C63 VPB VNB 0.9419f
C64 a_225_74# VNB 0.04951f
C65 a_399_368# VNB 0.04548f
C66 a_223_368# VNB 0.00384f
C67 a_114_74# VNB 0.1168f
.ends

.subckt ra_nor2_1 VNB VPB VPWR VGND B Y A a_116_368#
X0 a_116_368# A VPWR VPB sky130_fd_pr__pfet_01v8 ad=0.1512 pd=1.39 as=0.3304 ps=2.83 w=1.12 l=0.15
X1 Y A VGND VNB sky130_fd_pr__nfet_01v8_lvt ad=0.1036 pd=1.02 as=0.2109 ps=2.05 w=0.74 l=0.15
X2 Y B a_116_368# VPB sky130_fd_pr__pfet_01v8 ad=0.3304 pd=2.83 as=0.1512 ps=1.39 w=1.12 l=0.15
X3 VGND B Y VNB sky130_fd_pr__nfet_01v8_lvt ad=0.2109 pd=2.05 as=0.1036 ps=1.02 w=0.74 l=0.15
C0 VGND B 0.05271f
C1 VPB B 0.04197f
C2 VPWR Y 0.14249f
C3 VGND A 0.04716f
C4 a_116_368# VPWR 0.00544f
C5 VPB A 0.04145f
C6 B VPWR 0.00749f
C7 a_116_368# Y 0.01586f
C8 B Y 0.10975f
C9 VGND VPB 0.00497f
C10 A VPWR 0.05547f
C11 A Y 0.06451f
C12 VGND VPWR 0.02669f
C13 A B 0.06143f
C14 VPB VPWR 0.05537f
C15 VGND Y 0.16016f
C16 VPB Y 0.01485f
C17 VGND a_116_368# 0
C18 VGND VNB 0.29794f
C19 Y VNB 0.06414f
C20 VPWR VNB 0.21891f
C21 B VNB 0.13382f
C22 A VNB 0.13353f
C23 VPB VNB 0.40622f
.ends

.subckt dfxtp_1_ra VNB VPB VPWR VGND CLK Q D a_1011_424# a_1210_314#
+ a_1168_124# a_561_463# a_731_101# a_27_74# a_206_368# a_668_503# a_1118_508# a_454_503#
+ a_713_458#
X0 VPWR CLK a_27_74# VPB sky130_fd_pr__pfet_01v8 ad=0.168 pd=1.42 as=0.3304 ps=2.83 w=1.12 l=0.15
X1 a_668_503# a_27_74# a_561_463# VPB sky130_fd_pr__pfet_01v8 ad=0.0504 pd=0.66 as=0.09835 ps=1.005 w=0.42 l=0.15
X2 Q a_1210_314# VPWR VPB sky130_fd_pr__pfet_01v8 ad=0.3304 pd=2.83 as=0.1862 ps=1.475 w=1.12 l=0.15
X3 a_454_503# D VPWR VPB sky130_fd_pr__pfet_01v8 ad=0.09835 pd=1.005 as=0.2972 ps=2.41 w=0.42 l=0.15
X4 VPWR a_1011_424# a_1210_314# VPB sky130_fd_pr__pfet_01v8 ad=0.1862 pd=1.475 as=0.2478 ps=2.27 w=0.84 l=0.15
X5 VGND CLK a_27_74# VNB sky130_fd_pr__nfet_01v8_lvt ad=0.1739 pd=1.21 as=0.2109 ps=2.05 w=0.74 l=0.15
X6 a_1118_508# a_206_368# a_1011_424# VPB sky130_fd_pr__pfet_01v8 ad=0.09975 pd=0.895 as=0.1428 ps=1.225 w=0.42 l=0.15
X7 VGND a_1210_314# a_1168_124# VNB sky130_fd_pr__nfet_01v8_lvt ad=0.1197 pd=1.41 as=0.05565 ps=0.685 w=0.42 l=0.15
X8 a_713_458# a_561_463# VGND VNB sky130_fd_pr__nfet_01v8_lvt ad=0.10905 pd=1.025 as=0.1648 ps=1.245 w=0.55 l=0.15
X9 VGND a_713_458# a_731_101# VNB sky130_fd_pr__nfet_01v8_lvt ad=0.1648 pd=1.245 as=0.0441 ps=0.63 w=0.42 l=0.15
X10 a_561_463# a_206_368# a_454_503# VPB sky130_fd_pr__pfet_01v8 ad=0.09835 pd=1.005 as=0.09835 ps=1.005 w=0.42 l=0.15
X11 a_206_368# a_27_74# VPWR VPB sky130_fd_pr__pfet_01v8 ad=0.3304 pd=2.83 as=0.168 ps=1.42 w=1.12 l=0.15
X12 a_1011_424# a_27_74# a_713_458# VPB sky130_fd_pr__pfet_01v8 ad=0.1428 pd=1.225 as=0.2331 ps=1.395 w=0.84 l=0.15
X13 VPWR a_1210_314# a_1118_508# VPB sky130_fd_pr__pfet_01v8 ad=0.1239 pd=1.43 as=0.09975 ps=0.895 w=0.42 l=0.15
X14 a_1168_124# a_27_74# a_1011_424# VNB sky130_fd_pr__nfet_01v8_lvt ad=0.05565 pd=0.685 as=0.1181 ps=1.035 w=0.42 l=0.15
X15 Q a_1210_314# VGND VNB sky130_fd_pr__nfet_01v8_lvt ad=0.2109 pd=2.05 as=0.1229 ps=1.085 w=0.74 l=0.15
X16 a_713_458# a_561_463# VPWR VPB sky130_fd_pr__pfet_01v8 ad=0.2331 pd=1.395 as=0.18985 ps=1.545 w=0.84 l=0.15
X17 a_561_463# a_27_74# a_454_503# VNB sky130_fd_pr__nfet_01v8_lvt ad=0.07875 pd=0.865 as=0.15563 ps=1.215 w=0.42 l=0.15
X18 VPWR a_713_458# a_668_503# VPB sky130_fd_pr__pfet_01v8 ad=0.18985 pd=1.545 as=0.0504 ps=0.66 w=0.42 l=0.15
X19 VGND a_1011_424# a_1210_314# VNB sky130_fd_pr__nfet_01v8_lvt ad=0.1229 pd=1.085 as=0.1824 ps=1.85 w=0.64 l=0.15
X20 a_206_368# a_27_74# VGND VNB sky130_fd_pr__nfet_01v8_lvt ad=0.2553 pd=2.17 as=0.1739 ps=1.21 w=0.74 l=0.15
X21 a_731_101# a_206_368# a_561_463# VNB sky130_fd_pr__nfet_01v8_lvt ad=0.0441 pd=0.63 as=0.07875 ps=0.865 w=0.42 l=0.15
X22 a_1011_424# a_206_368# a_713_458# VNB sky130_fd_pr__nfet_01v8_lvt ad=0.1181 pd=1.035 as=0.10905 ps=1.025 w=0.55 l=0.15
X23 a_454_503# D VGND VNB sky130_fd_pr__nfet_01v8_lvt ad=0.15563 pd=1.215 as=0.23015 ps=2.1 w=0.42 l=0.15
C0 VPWR a_1011_424# 0.02994f
C1 a_668_503# a_561_463# 0.00153f
C2 a_27_74# CLK 0.20893f
C3 VPB VGND 0.01901f
C4 a_1168_124# VGND 0.00661f
C5 a_27_74# a_1210_314# 0.0649f
C6 a_206_368# a_561_463# 0.18757f
C7 a_1011_424# VGND 0.08448f
C8 a_668_503# VPWR 0.00118f
C9 a_27_74# D 0.05673f
C10 VPB a_713_458# 0.08413f
C11 VPWR a_206_368# 0.54604f
C12 a_1168_124# a_713_458# 0
C13 a_27_74# a_454_503# 0.04602f
C14 a_668_503# VGND 0
C15 a_1011_424# a_713_458# 0.02621f
C16 a_27_74# Q 0
C17 a_206_368# VGND 0.09411f
C18 a_1011_424# a_1118_508# 0
C19 Q a_1210_314# 0.11821f
C20 a_454_503# D 0.1153f
C21 VPB a_1011_424# 0.05565f
C22 a_1011_424# a_1168_124# 0.00536f
C23 a_206_368# a_713_458# 0.21375f
C24 a_27_74# a_561_463# 0.35097f
C25 a_27_74# a_731_101# 0.00541f
C26 a_206_368# a_1118_508# 0.00869f
C27 a_561_463# a_1210_314# 0
C28 VPWR a_27_74# 0.15897f
C29 VPB a_206_368# 0.28245f
C30 VPWR CLK 0.01777f
C31 a_561_463# D 0.00175f
C32 VPWR a_1210_314# 0.18807f
C33 a_206_368# a_1011_424# 0.29279f
C34 a_561_463# a_454_503# 0.14439f
C35 a_27_74# VGND 0.77625f
C36 VGND CLK 0.01715f
C37 VPWR D 0.01123f
C38 VGND a_1210_314# 0.18024f
C39 Q a_561_463# 0
C40 a_668_503# a_206_368# 0.00549f
C41 VPWR a_454_503# 0.0081f
C42 VGND D 0.00938f
C43 a_27_74# a_713_458# 0.27693f
C44 VPWR Q 0.11977f
C45 VGND a_454_503# 0.00682f
C46 a_713_458# a_1210_314# 0
C47 a_731_101# a_561_463# 0
C48 a_1118_508# a_1210_314# 0
C49 VGND Q 0.06867f
C50 VPB a_27_74# 0.22737f
C51 VPB CLK 0.0398f
C52 a_27_74# a_1168_124# 0
C53 VPWR a_561_463# 0.03222f
C54 VPB a_1210_314# 0.18221f
C55 a_27_74# a_1011_424# 0.08774f
C56 VPWR a_731_101# 0
C57 a_1011_424# a_1210_314# 0.30231f
C58 VPB D 0.09818f
C59 VGND a_561_463# 0.0157f
C60 Q a_713_458# 0
C61 a_731_101# VGND 0
C62 VPB a_454_503# 0.01026f
C63 a_27_74# a_206_368# 0.54419f
C64 a_206_368# CLK 0
C65 VPWR VGND 0.1274f
C66 VPB Q 0.01364f
C67 a_713_458# a_561_463# 0.22581f
C68 a_206_368# a_1210_314# 0.06302f
C69 a_1011_424# Q 0.0023f
C70 a_731_101# a_713_458# 0
C71 a_206_368# D 0.24761f
C72 VPB a_561_463# 0.10382f
C73 VPWR a_713_458# 0.01891f
C74 a_206_368# a_454_503# 0.05569f
C75 VPWR a_1118_508# 0.00664f
C76 a_1011_424# a_561_463# 0
C77 VGND a_713_458# 0.02548f
C78 a_206_368# Q 0
C79 VPB VPWR 0.26584f
C80 a_1118_508# VGND 0
C81 VPWR a_1168_124# 0
C82 Q VNB 0.11123f
C83 VGND VNB 0.9441f
C84 D VNB 0.09655f
C85 CLK VNB 0.13046f
C86 VPWR VNB 0.72899f
C87 VPB VNB 1.90613f
C88 a_1011_424# VNB 0.1356f
C89 a_454_503# VNB 0.00941f
C90 a_1210_314# VNB 0.2091f
C91 a_561_463# VNB 0.12443f
C92 a_713_458# VNB 0.14087f
C93 a_206_368# VNB 0.56488f
C94 a_27_74# VNB 0.45754f
.ends

.subckt register_array clk reset enable count.0 count.1 count.2 count.3 count.4 count.5 count.6 count.7 stored_values.0 stored_values.1 stored_values.2 stored_values.3 stored_values.4 stored_values.5 stored_values.6 stored_values.7 VGND VPWR
Xsky130_fd_sc_hs__mux2i_1_0 VGND VPWR VPWR VGND enable count.4 stored_values.4 sky130_fd_sc_hs__nor2_1_2/B
+ sky130_fd_sc_hs__mux2i_1_0/a_225_74# sky130_fd_sc_hs__mux2i_1_0/a_399_368# sky130_fd_sc_hs__mux2i_1_0/a_223_368#
+ sky130_fd_sc_hs__mux2i_1_0/a_114_74# sky130_fd_sc_hs__mux2i_1_0/a_426_74# ra_mux2i_1
Xsky130_fd_sc_hs__mux2i_1_1 VGND VPWR VPWR VGND enable count.6 stored_values.6 sky130_fd_sc_hs__nor2_1_5/B
+ sky130_fd_sc_hs__mux2i_1_1/a_225_74# sky130_fd_sc_hs__mux2i_1_1/a_399_368# sky130_fd_sc_hs__mux2i_1_1/a_223_368#
+ sky130_fd_sc_hs__mux2i_1_1/a_114_74# sky130_fd_sc_hs__mux2i_1_1/a_426_74# ra_mux2i_1
Xsky130_fd_sc_hs__mux2i_1_2 VGND VPWR VPWR VGND enable count.5 stored_values.5 sky130_fd_sc_hs__nor2_1_4/B
+ sky130_fd_sc_hs__mux2i_1_2/a_225_74# sky130_fd_sc_hs__mux2i_1_2/a_399_368# sky130_fd_sc_hs__mux2i_1_2/a_223_368#
+ sky130_fd_sc_hs__mux2i_1_2/a_114_74# sky130_fd_sc_hs__mux2i_1_2/a_426_74# ra_mux2i_1
Xsky130_fd_sc_hs__mux2i_1_3 VGND VPWR VPWR VGND enable count.7 stored_values.7 sky130_fd_sc_hs__nor2_1_3/B
+ sky130_fd_sc_hs__mux2i_1_3/a_225_74# sky130_fd_sc_hs__mux2i_1_3/a_399_368# sky130_fd_sc_hs__mux2i_1_3/a_223_368#
+ sky130_fd_sc_hs__mux2i_1_3/a_114_74# sky130_fd_sc_hs__mux2i_1_3/a_426_74# ra_mux2i_1
Xsky130_fd_sc_hs__nor2_1_0 VGND VPWR VPWR VGND sky130_fd_sc_hs__nor2_1_0/B sky130_fd_sc_hs__nor2_1_0/Y
+ reset sky130_fd_sc_hs__nor2_1_0/a_116_368# ra_nor2_1
Xsky130_fd_sc_hs__nor2_1_1 VGND VPWR VPWR VGND sky130_fd_sc_hs__nor2_1_1/B sky130_fd_sc_hs__nor2_1_1/Y
+ reset sky130_fd_sc_hs__nor2_1_1/a_116_368# ra_nor2_1
Xsky130_fd_sc_hs__dfxtp_1_0 VGND VPWR VPWR VGND clk stored_values.3 sky130_fd_sc_hs__nor2_1_1/Y
+ sky130_fd_sc_hs__dfxtp_1_0/a_1011_424# sky130_fd_sc_hs__dfxtp_1_0/a_1210_314# sky130_fd_sc_hs__dfxtp_1_0/a_1168_124#
+ sky130_fd_sc_hs__dfxtp_1_0/a_561_463# sky130_fd_sc_hs__dfxtp_1_0/a_731_101# sky130_fd_sc_hs__dfxtp_1_0/a_27_74#
+ sky130_fd_sc_hs__dfxtp_1_0/a_206_368# sky130_fd_sc_hs__dfxtp_1_0/a_668_503# sky130_fd_sc_hs__dfxtp_1_0/a_1118_508#
+ sky130_fd_sc_hs__dfxtp_1_0/a_454_503# sky130_fd_sc_hs__dfxtp_1_0/a_713_458# dfxtp_1_ra
Xsky130_fd_sc_hs__mux2i_1_5 VGND VPWR VPWR VGND enable count.2 stored_values.2 sky130_fd_sc_hs__nor2_1_6/B
+ sky130_fd_sc_hs__mux2i_1_5/a_225_74# sky130_fd_sc_hs__mux2i_1_5/a_399_368# sky130_fd_sc_hs__mux2i_1_5/a_223_368#
+ sky130_fd_sc_hs__mux2i_1_5/a_114_74# sky130_fd_sc_hs__mux2i_1_5/a_426_74# ra_mux2i_1
Xsky130_fd_sc_hs__mux2i_1_4 VGND VPWR VPWR VGND enable count.0 stored_values.0 sky130_fd_sc_hs__nor2_1_0/B
+ sky130_fd_sc_hs__mux2i_1_4/a_225_74# sky130_fd_sc_hs__mux2i_1_4/a_399_368# sky130_fd_sc_hs__mux2i_1_4/a_223_368#
+ sky130_fd_sc_hs__mux2i_1_4/a_114_74# sky130_fd_sc_hs__mux2i_1_4/a_426_74# ra_mux2i_1
Xsky130_fd_sc_hs__dfxtp_1_1 VGND VPWR VPWR VGND clk stored_values.7 sky130_fd_sc_hs__nor2_1_3/Y
+ sky130_fd_sc_hs__dfxtp_1_1/a_1011_424# sky130_fd_sc_hs__dfxtp_1_1/a_1210_314# sky130_fd_sc_hs__dfxtp_1_1/a_1168_124#
+ sky130_fd_sc_hs__dfxtp_1_1/a_561_463# sky130_fd_sc_hs__dfxtp_1_1/a_731_101# sky130_fd_sc_hs__dfxtp_1_1/a_27_74#
+ sky130_fd_sc_hs__dfxtp_1_1/a_206_368# sky130_fd_sc_hs__dfxtp_1_1/a_668_503# sky130_fd_sc_hs__dfxtp_1_1/a_1118_508#
+ sky130_fd_sc_hs__dfxtp_1_1/a_454_503# sky130_fd_sc_hs__dfxtp_1_1/a_713_458# dfxtp_1_ra
Xsky130_fd_sc_hs__mux2i_1_6 VGND VPWR VPWR VGND enable count.1 stored_values.1 sky130_fd_sc_hs__nor2_1_7/B
+ sky130_fd_sc_hs__mux2i_1_6/a_225_74# sky130_fd_sc_hs__mux2i_1_6/a_399_368# sky130_fd_sc_hs__mux2i_1_6/a_223_368#
+ sky130_fd_sc_hs__mux2i_1_6/a_114_74# sky130_fd_sc_hs__mux2i_1_6/a_426_74# ra_mux2i_1
Xsky130_fd_sc_hs__dfxtp_1_2 VGND VPWR VPWR VGND clk stored_values.4 sky130_fd_sc_hs__nor2_1_2/Y
+ sky130_fd_sc_hs__dfxtp_1_2/a_1011_424# sky130_fd_sc_hs__dfxtp_1_2/a_1210_314# sky130_fd_sc_hs__dfxtp_1_2/a_1168_124#
+ sky130_fd_sc_hs__dfxtp_1_2/a_561_463# sky130_fd_sc_hs__dfxtp_1_2/a_731_101# sky130_fd_sc_hs__dfxtp_1_2/a_27_74#
+ sky130_fd_sc_hs__dfxtp_1_2/a_206_368# sky130_fd_sc_hs__dfxtp_1_2/a_668_503# sky130_fd_sc_hs__dfxtp_1_2/a_1118_508#
+ sky130_fd_sc_hs__dfxtp_1_2/a_454_503# sky130_fd_sc_hs__dfxtp_1_2/a_713_458# dfxtp_1_ra
Xsky130_fd_sc_hs__nor2_1_2 VGND VPWR VPWR VGND sky130_fd_sc_hs__nor2_1_2/B sky130_fd_sc_hs__nor2_1_2/Y
+ reset sky130_fd_sc_hs__nor2_1_2/a_116_368# ra_nor2_1
Xsky130_fd_sc_hs__mux2i_1_7 VGND VPWR VPWR VGND enable count.3 stored_values.3 sky130_fd_sc_hs__nor2_1_1/B
+ sky130_fd_sc_hs__mux2i_1_7/a_225_74# sky130_fd_sc_hs__mux2i_1_7/a_399_368# sky130_fd_sc_hs__mux2i_1_7/a_223_368#
+ sky130_fd_sc_hs__mux2i_1_7/a_114_74# sky130_fd_sc_hs__mux2i_1_7/a_426_74# ra_mux2i_1
Xsky130_fd_sc_hs__nor2_1_3 VGND VPWR VPWR VGND sky130_fd_sc_hs__nor2_1_3/B sky130_fd_sc_hs__nor2_1_3/Y
+ reset sky130_fd_sc_hs__nor2_1_3/a_116_368# ra_nor2_1
Xsky130_fd_sc_hs__dfxtp_1_3 VGND VPWR VPWR VGND clk stored_values.5 sky130_fd_sc_hs__nor2_1_4/Y
+ sky130_fd_sc_hs__dfxtp_1_3/a_1011_424# sky130_fd_sc_hs__dfxtp_1_3/a_1210_314# sky130_fd_sc_hs__dfxtp_1_3/a_1168_124#
+ sky130_fd_sc_hs__dfxtp_1_3/a_561_463# sky130_fd_sc_hs__dfxtp_1_3/a_731_101# sky130_fd_sc_hs__dfxtp_1_3/a_27_74#
+ sky130_fd_sc_hs__dfxtp_1_3/a_206_368# sky130_fd_sc_hs__dfxtp_1_3/a_668_503# sky130_fd_sc_hs__dfxtp_1_3/a_1118_508#
+ sky130_fd_sc_hs__dfxtp_1_3/a_454_503# sky130_fd_sc_hs__dfxtp_1_3/a_713_458# dfxtp_1_ra
Xsky130_fd_sc_hs__nor2_1_4 VGND VPWR VPWR VGND sky130_fd_sc_hs__nor2_1_4/B sky130_fd_sc_hs__nor2_1_4/Y
+ reset sky130_fd_sc_hs__nor2_1_4/a_116_368# ra_nor2_1
Xsky130_fd_sc_hs__dfxtp_1_4 VGND VPWR VPWR VGND clk stored_values.1 sky130_fd_sc_hs__nor2_1_7/Y
+ sky130_fd_sc_hs__dfxtp_1_4/a_1011_424# sky130_fd_sc_hs__dfxtp_1_4/a_1210_314# sky130_fd_sc_hs__dfxtp_1_4/a_1168_124#
+ sky130_fd_sc_hs__dfxtp_1_4/a_561_463# sky130_fd_sc_hs__dfxtp_1_4/a_731_101# sky130_fd_sc_hs__dfxtp_1_4/a_27_74#
+ sky130_fd_sc_hs__dfxtp_1_4/a_206_368# sky130_fd_sc_hs__dfxtp_1_4/a_668_503# sky130_fd_sc_hs__dfxtp_1_4/a_1118_508#
+ sky130_fd_sc_hs__dfxtp_1_4/a_454_503# sky130_fd_sc_hs__dfxtp_1_4/a_713_458# dfxtp_1_ra
Xsky130_fd_sc_hs__nor2_1_5 VGND VPWR VPWR VGND sky130_fd_sc_hs__nor2_1_5/B sky130_fd_sc_hs__nor2_1_5/Y
+ reset sky130_fd_sc_hs__nor2_1_5/a_116_368# ra_nor2_1
Xsky130_fd_sc_hs__dfxtp_1_5 VGND VPWR VPWR VGND clk stored_values.2 sky130_fd_sc_hs__nor2_1_6/Y
+ sky130_fd_sc_hs__dfxtp_1_5/a_1011_424# sky130_fd_sc_hs__dfxtp_1_5/a_1210_314# sky130_fd_sc_hs__dfxtp_1_5/a_1168_124#
+ sky130_fd_sc_hs__dfxtp_1_5/a_561_463# sky130_fd_sc_hs__dfxtp_1_5/a_731_101# sky130_fd_sc_hs__dfxtp_1_5/a_27_74#
+ sky130_fd_sc_hs__dfxtp_1_5/a_206_368# sky130_fd_sc_hs__dfxtp_1_5/a_668_503# sky130_fd_sc_hs__dfxtp_1_5/a_1118_508#
+ sky130_fd_sc_hs__dfxtp_1_5/a_454_503# sky130_fd_sc_hs__dfxtp_1_5/a_713_458# dfxtp_1_ra
Xsky130_fd_sc_hs__nor2_1_6 VGND VPWR VPWR VGND sky130_fd_sc_hs__nor2_1_6/B sky130_fd_sc_hs__nor2_1_6/Y
+ reset sky130_fd_sc_hs__nor2_1_6/a_116_368# ra_nor2_1
Xsky130_fd_sc_hs__dfxtp_1_6 VGND VPWR VPWR VGND clk stored_values.0 sky130_fd_sc_hs__nor2_1_0/Y
+ sky130_fd_sc_hs__dfxtp_1_6/a_1011_424# sky130_fd_sc_hs__dfxtp_1_6/a_1210_314# sky130_fd_sc_hs__dfxtp_1_6/a_1168_124#
+ sky130_fd_sc_hs__dfxtp_1_6/a_561_463# sky130_fd_sc_hs__dfxtp_1_6/a_731_101# sky130_fd_sc_hs__dfxtp_1_6/a_27_74#
+ sky130_fd_sc_hs__dfxtp_1_6/a_206_368# sky130_fd_sc_hs__dfxtp_1_6/a_668_503# sky130_fd_sc_hs__dfxtp_1_6/a_1118_508#
+ sky130_fd_sc_hs__dfxtp_1_6/a_454_503# sky130_fd_sc_hs__dfxtp_1_6/a_713_458# dfxtp_1_ra
Xsky130_fd_sc_hs__nor2_1_7 VGND VPWR VPWR VGND sky130_fd_sc_hs__nor2_1_7/B sky130_fd_sc_hs__nor2_1_7/Y
+ reset sky130_fd_sc_hs__nor2_1_7/a_116_368# ra_nor2_1
Xsky130_fd_sc_hs__dfxtp_1_7 VGND VPWR VPWR VGND clk stored_values.6 sky130_fd_sc_hs__nor2_1_5/Y
+ sky130_fd_sc_hs__dfxtp_1_7/a_1011_424# sky130_fd_sc_hs__dfxtp_1_7/a_1210_314# sky130_fd_sc_hs__dfxtp_1_7/a_1168_124#
+ sky130_fd_sc_hs__dfxtp_1_7/a_561_463# sky130_fd_sc_hs__dfxtp_1_7/a_731_101# sky130_fd_sc_hs__dfxtp_1_7/a_27_74#
+ sky130_fd_sc_hs__dfxtp_1_7/a_206_368# sky130_fd_sc_hs__dfxtp_1_7/a_668_503# sky130_fd_sc_hs__dfxtp_1_7/a_1118_508#
+ sky130_fd_sc_hs__dfxtp_1_7/a_454_503# sky130_fd_sc_hs__dfxtp_1_7/a_713_458# dfxtp_1_ra
C0 clk sky130_fd_sc_hs__mux2i_1_1/a_426_74# 0
C1 sky130_fd_sc_hs__nor2_1_7/B sky130_fd_sc_hs__mux2i_1_2/a_225_74# 0.00202f
C2 sky130_fd_sc_hs__dfxtp_1_6/a_1011_424# sky130_fd_sc_hs__nor2_1_0/Y 0
C3 sky130_fd_sc_hs__dfxtp_1_2/a_1011_424# reset 0.00432f
C4 reset sky130_fd_sc_hs__nor2_1_4/B 0.15097f
C5 sky130_fd_sc_hs__dfxtp_1_2/a_206_368# count.4 0.0027f
C6 sky130_fd_sc_hs__dfxtp_1_3/a_206_368# count.5 0.00305f
C7 sky130_fd_sc_hs__dfxtp_1_7/a_1011_424# sky130_fd_sc_hs__mux2i_1_3/a_223_368# 0
C8 sky130_fd_sc_hs__mux2i_1_7/a_426_74# sky130_fd_sc_hs__nor2_1_1/B 0.00146f
C9 sky130_fd_sc_hs__mux2i_1_7/a_399_368# sky130_fd_sc_hs__nor2_1_1/Y 0.00524f
C10 sky130_fd_sc_hs__dfxtp_1_7/a_1210_314# sky130_fd_sc_hs__nor2_1_5/B 0
C11 sky130_fd_sc_hs__nor2_1_2/B count.0 0
C12 sky130_fd_sc_hs__dfxtp_1_3/a_1210_314# sky130_fd_sc_hs__nor2_1_5/Y 0
C13 reset sky130_fd_sc_hs__dfxtp_1_7/a_1210_314# 0.00617f
C14 reset sky130_fd_sc_hs__dfxtp_1_6/a_1168_124# 0
C15 sky130_fd_sc_hs__nor2_1_6/B sky130_fd_sc_hs__nor2_1_6/Y 0.05741f
C16 clk sky130_fd_sc_hs__dfxtp_1_3/a_206_368# 0.00998f
C17 sky130_fd_sc_hs__nor2_1_7/B count.1 0.05673f
C18 sky130_fd_sc_hs__mux2i_1_0/a_114_74# stored_values.4 0.02003f
C19 sky130_fd_sc_hs__dfxtp_1_4/a_454_503# stored_values.1 0.01366f
C20 VPWR sky130_fd_sc_hs__nor2_1_1/Y 0.0087f
C21 count.3 sky130_fd_sc_hs__dfxtp_1_5/a_561_463# 0
C22 VPWR sky130_fd_sc_hs__mux2i_1_6/a_399_368# 0.06799f
C23 sky130_fd_sc_hs__dfxtp_1_4/a_1210_314# sky130_fd_sc_hs__dfxtp_1_5/a_27_74# 0
C24 reset sky130_fd_sc_hs__mux2i_1_5/a_114_74# 0.0045f
C25 sky130_fd_sc_hs__dfxtp_1_0/a_27_74# enable 0
C26 sky130_fd_sc_hs__mux2i_1_2/a_114_74# stored_values.5 0.01854f
C27 sky130_fd_sc_hs__dfxtp_1_0/a_1011_424# sky130_fd_sc_hs__dfxtp_1_1/a_1011_424# 0.00396f
C28 sky130_fd_sc_hs__dfxtp_1_2/a_27_74# sky130_fd_sc_hs__nor2_1_2/B 0.01105f
C29 count.4 sky130_fd_sc_hs__nor2_1_2/B 0.07175f
C30 clk sky130_fd_sc_hs__dfxtp_1_4/a_454_503# 0.00382f
C31 stored_values.7 sky130_fd_sc_hs__dfxtp_1_7/a_668_503# 0
C32 stored_values.6 sky130_fd_sc_hs__mux2i_1_3/a_223_368# 0
C33 sky130_fd_sc_hs__dfxtp_1_0/a_713_458# sky130_fd_sc_hs__dfxtp_1_1/a_713_458# 0.00476f
C34 VPWR sky130_fd_sc_hs__dfxtp_1_1/a_668_503# -0
C35 VPWR sky130_fd_sc_hs__dfxtp_1_2/a_1168_124# -0
C36 sky130_fd_sc_hs__dfxtp_1_3/a_713_458# count.5 0
C37 sky130_fd_sc_hs__dfxtp_1_3/a_561_463# stored_values.5 0.06069f
C38 sky130_fd_sc_hs__dfxtp_1_4/a_27_74# sky130_fd_sc_hs__mux2i_1_5/a_225_74# 0
C39 sky130_fd_sc_hs__dfxtp_1_4/a_713_458# sky130_fd_sc_hs__mux2i_1_5/a_223_368# 0
C40 sky130_fd_sc_hs__dfxtp_1_4/a_206_368# sky130_fd_sc_hs__mux2i_1_5/a_399_368# 0
C41 sky130_fd_sc_hs__nor2_1_4/a_116_368# reset 0
C42 clk sky130_fd_sc_hs__dfxtp_1_3/a_713_458# 0.00202f
C43 stored_values.2 sky130_fd_sc_hs__nor2_1_6/B 0.06572f
C44 sky130_fd_sc_hs__dfxtp_1_3/a_1210_314# sky130_fd_sc_hs__dfxtp_1_7/a_27_74# 0
C45 VPWR sky130_fd_sc_hs__dfxtp_1_7/a_1011_424# -0.01088f
C46 count.2 count.6 0.00462f
C47 VPWR sky130_fd_sc_hs__mux2i_1_5/a_225_74# -0.00113f
C48 sky130_fd_sc_hs__dfxtp_1_0/a_27_74# sky130_fd_sc_hs__dfxtp_1_1/a_713_458# 0
C49 sky130_fd_sc_hs__dfxtp_1_0/a_206_368# sky130_fd_sc_hs__dfxtp_1_1/a_206_368# 0.05752f
C50 reset sky130_fd_sc_hs__mux2i_1_3/a_225_74# 0.0073f
C51 sky130_fd_sc_hs__dfxtp_1_2/a_454_503# reset 0.00224f
C52 sky130_fd_sc_hs__dfxtp_1_7/a_731_101# sky130_fd_sc_hs__nor2_1_3/B 0
C53 sky130_fd_sc_hs__nor2_1_4/Y enable 0.0014f
C54 sky130_fd_sc_hs__dfxtp_1_4/a_1011_424# sky130_fd_sc_hs__nor2_1_6/Y 0
C55 reset sky130_fd_sc_hs__dfxtp_1_6/a_206_368# 0.00504f
C56 sky130_fd_sc_hs__mux2i_1_6/a_399_368# count.1 0.02304f
C57 sky130_fd_sc_hs__mux2i_1_6/a_225_74# stored_values.1 0.00201f
C58 sky130_fd_sc_hs__nor2_1_1/Y sky130_fd_sc_hs__dfxtp_1_5/a_27_74# 0
C59 sky130_fd_sc_hs__nor2_1_1/B sky130_fd_sc_hs__dfxtp_1_5/a_713_458# 0
C60 VPWR sky130_fd_sc_hs__nor2_1_2/a_116_368# -0
C61 stored_values.3 sky130_fd_sc_hs__nor2_1_3/B 0.00112f
C62 VPWR stored_values.6 1.28845f
C63 clk sky130_fd_sc_hs__mux2i_1_0/a_426_74# 0
C64 sky130_fd_sc_hs__mux2i_1_6/a_225_74# count.5 0
C65 sky130_fd_sc_hs__mux2i_1_5/a_223_368# sky130_fd_sc_hs__nor2_1_7/Y 0
C66 sky130_fd_sc_hs__dfxtp_1_3/a_1118_508# stored_values.6 0
C67 sky130_fd_sc_hs__dfxtp_1_3/a_1011_424# count.6 0
C68 sky130_fd_sc_hs__nor2_1_7/B sky130_fd_sc_hs__dfxtp_1_6/a_27_74# 0
C69 sky130_fd_sc_hs__dfxtp_1_5/a_731_101# sky130_fd_sc_hs__nor2_1_1/B 0
C70 sky130_fd_sc_hs__dfxtp_1_5/a_1011_424# sky130_fd_sc_hs__nor2_1_1/Y 0
C71 sky130_fd_sc_hs__nor2_1_3/a_116_368# sky130_fd_sc_hs__nor2_1_3/B 0
C72 clk sky130_fd_sc_hs__mux2i_1_6/a_225_74# 0.00228f
C73 sky130_fd_sc_hs__dfxtp_1_4/a_713_458# reset 0.00188f
C74 sky130_fd_sc_hs__nor2_1_3/B sky130_fd_sc_hs__dfxtp_1_1/a_27_74# 0.00792f
C75 sky130_fd_sc_hs__mux2i_1_4/a_426_74# enable 0
C76 sky130_fd_sc_hs__dfxtp_1_4/a_27_74# sky130_fd_sc_hs__dfxtp_1_3/a_206_368# 0
C77 sky130_fd_sc_hs__dfxtp_1_4/a_206_368# sky130_fd_sc_hs__dfxtp_1_3/a_27_74# 0
C78 sky130_fd_sc_hs__mux2i_1_0/a_399_368# sky130_fd_sc_hs__nor2_1_0/B 0
C79 sky130_fd_sc_hs__nor2_1_4/Y sky130_fd_sc_hs__dfxtp_1_3/a_454_503# 0.00374f
C80 reset sky130_fd_sc_hs__mux2i_1_7/a_426_74# 0
C81 sky130_fd_sc_hs__nor2_1_4/Y sky130_fd_sc_hs__dfxtp_1_2/a_206_368# 0
C82 sky130_fd_sc_hs__mux2i_1_3/a_426_74# enable 0
C83 sky130_fd_sc_hs__dfxtp_1_0/a_454_503# enable 0
C84 sky130_fd_sc_hs__dfxtp_1_2/a_731_101# sky130_fd_sc_hs__nor2_1_4/B 0
C85 sky130_fd_sc_hs__dfxtp_1_6/a_561_463# enable 0.0027f
C86 stored_values.2 sky130_fd_sc_hs__dfxtp_1_4/a_1011_424# 0
C87 sky130_fd_sc_hs__dfxtp_1_7/a_1011_424# sky130_fd_sc_hs__dfxtp_1_5/a_27_74# 0
C88 sky130_fd_sc_hs__mux2i_1_4/a_225_74# sky130_fd_sc_hs__nor2_1_0/B 0.0297f
C89 VPWR sky130_fd_sc_hs__dfxtp_1_3/a_206_368# -0.03902f
C90 clk sky130_fd_sc_hs__dfxtp_1_1/a_1011_424# 0.00127f
C91 VPWR sky130_fd_sc_hs__mux2i_1_4/a_223_368# -0.00738f
C92 sky130_fd_sc_hs__dfxtp_1_4/a_206_368# sky130_fd_sc_hs__nor2_1_7/B 0.00225f
C93 clk sky130_fd_sc_hs__dfxtp_1_0/a_1118_508# 0
C94 sky130_fd_sc_hs__nor2_1_7/B sky130_fd_sc_hs__dfxtp_1_6/a_1011_424# 0
C95 sky130_fd_sc_hs__dfxtp_1_4/a_713_458# sky130_fd_sc_hs__dfxtp_1_4/a_561_463# 0
C96 sky130_fd_sc_hs__dfxtp_1_5/a_1210_314# sky130_fd_sc_hs__dfxtp_1_0/a_27_74# 0
C97 count.7 enable 0.00283f
C98 sky130_fd_sc_hs__mux2i_1_5/a_399_368# sky130_fd_sc_hs__dfxtp_1_5/a_206_368# 0
C99 sky130_fd_sc_hs__dfxtp_1_6/a_713_458# sky130_fd_sc_hs__nor2_1_0/B 0
C100 sky130_fd_sc_hs__dfxtp_1_6/a_454_503# stored_values.0 0.01862f
C101 sky130_fd_sc_hs__nor2_1_3/Y sky130_fd_sc_hs__nor2_1_1/Y 0
C102 sky130_fd_sc_hs__nor2_1_2/Y sky130_fd_sc_hs__dfxtp_1_2/a_561_463# 0.00382f
C103 sky130_fd_sc_hs__dfxtp_1_7/a_1011_424# sky130_fd_sc_hs__dfxtp_1_5/a_1011_424# 0.00381f
C104 stored_values.3 sky130_fd_sc_hs__dfxtp_1_0/a_1011_424# 0.02788f
C105 sky130_fd_sc_hs__dfxtp_1_2/a_1210_314# sky130_fd_sc_hs__dfxtp_1_3/a_206_368# 0
C106 sky130_fd_sc_hs__dfxtp_1_3/a_454_503# enable 0
C107 stored_values.2 sky130_fd_sc_hs__dfxtp_1_4/a_1118_508# 0
C108 sky130_fd_sc_hs__mux2i_1_7/a_223_368# stored_values.3 0.05365f
C109 stored_values.4 sky130_fd_sc_hs__mux2i_1_0/a_399_368# 0.07014f
C110 count.0 sky130_fd_sc_hs__nor2_1_0/B 0.06041f
C111 VPWR sky130_fd_sc_hs__dfxtp_1_4/a_454_503# -0.00681f
C112 reset sky130_fd_sc_hs__nor2_1_7/Y 0.0122f
C113 sky130_fd_sc_hs__dfxtp_1_3/a_713_458# sky130_fd_sc_hs__dfxtp_1_4/a_27_74# 0
C114 sky130_fd_sc_hs__dfxtp_1_2/a_206_368# enable 0.00297f
C115 sky130_fd_sc_hs__nor2_1_1/B sky130_fd_sc_hs__nor2_1_1/a_116_368# 0
C116 reset sky130_fd_sc_hs__mux2i_1_0/a_223_368# 0.00345f
C117 sky130_fd_sc_hs__dfxtp_1_0/a_1011_424# sky130_fd_sc_hs__dfxtp_1_1/a_27_74# 0
C118 sky130_fd_sc_hs__dfxtp_1_2/a_713_458# sky130_fd_sc_hs__dfxtp_1_6/a_713_458# 0.00476f
C119 stored_values.1 sky130_fd_sc_hs__dfxtp_1_4/a_731_101# 0
C120 stored_values.4 sky130_fd_sc_hs__mux2i_1_4/a_225_74# 0
C121 sky130_fd_sc_hs__nor2_1_0/Y sky130_fd_sc_hs__dfxtp_1_6/a_206_368# 0.05693f
C122 reset sky130_fd_sc_hs__nor2_1_1/B 0.1584f
C123 sky130_fd_sc_hs__dfxtp_1_2/a_713_458# sky130_fd_sc_hs__mux2i_1_2/a_223_368# 0
C124 VPWR sky130_fd_sc_hs__dfxtp_1_3/a_713_458# -0.0086f
C125 clk count.6 0.00125f
C126 sky130_fd_sc_hs__nor2_1_6/B sky130_fd_sc_hs__dfxtp_1_5/a_454_503# 0
C127 sky130_fd_sc_hs__dfxtp_1_7/a_713_458# count.6 0
C128 sky130_fd_sc_hs__nor2_1_5/Y enable 0.00134f
C129 sky130_fd_sc_hs__dfxtp_1_7/a_561_463# stored_values.6 0.04651f
C130 stored_values.6 sky130_fd_sc_hs__dfxtp_1_5/a_1011_424# 0
C131 sky130_fd_sc_hs__dfxtp_1_3/a_206_368# sky130_fd_sc_hs__mux2i_1_2/a_225_74# 0
C132 count.4 sky130_fd_sc_hs__nor2_1_0/B 0.00829f
C133 sky130_fd_sc_hs__dfxtp_1_3/a_1168_124# enable 0
C134 sky130_fd_sc_hs__nor2_1_3/Y sky130_fd_sc_hs__dfxtp_1_7/a_1011_424# 0
C135 sky130_fd_sc_hs__dfxtp_1_4/a_561_463# sky130_fd_sc_hs__nor2_1_7/Y 0.00383f
C136 count.7 sky130_fd_sc_hs__dfxtp_1_1/a_713_458# 0
C137 stored_values.3 sky130_fd_sc_hs__dfxtp_1_1/a_1210_314# 0
C138 clk sky130_fd_sc_hs__dfxtp_1_4/a_731_101# 0
C139 stored_values.4 sky130_fd_sc_hs__mux2i_1_2/a_223_368# 0
C140 sky130_fd_sc_hs__nor2_1_2/B enable 0.00964f
C141 reset sky130_fd_sc_hs__dfxtp_1_5/a_713_458# 0.00187f
C142 count.3 sky130_fd_sc_hs__nor2_1_1/Y 0.01258f
C143 stored_values.7 sky130_fd_sc_hs__nor2_1_1/Y -0
C144 sky130_fd_sc_hs__dfxtp_1_2/a_713_458# count.4 0
C145 sky130_fd_sc_hs__dfxtp_1_2/a_1118_508# reset 0
C146 sky130_fd_sc_hs__dfxtp_1_4/a_206_368# sky130_fd_sc_hs__mux2i_1_6/a_399_368# 0
C147 sky130_fd_sc_hs__dfxtp_1_2/a_1011_424# sky130_fd_sc_hs__dfxtp_1_3/a_27_74# 0
C148 sky130_fd_sc_hs__dfxtp_1_3/a_27_74# sky130_fd_sc_hs__nor2_1_4/B 0.0091f
C149 sky130_fd_sc_hs__dfxtp_1_7/a_454_503# sky130_fd_sc_hs__nor2_1_5/B 0
C150 sky130_fd_sc_hs__dfxtp_1_7/a_1011_424# sky130_fd_sc_hs__mux2i_1_3/a_399_368# 0
C151 reset sky130_fd_sc_hs__dfxtp_1_7/a_454_503# 0.00217f
C152 clk sky130_fd_sc_hs__nor2_1_2/Y 0.04313f
C153 sky130_fd_sc_hs__mux2i_1_6/a_399_368# sky130_fd_sc_hs__dfxtp_1_6/a_1011_424# 0
C154 clk sky130_fd_sc_hs__mux2i_1_4/a_399_368# 0
C155 reset sky130_fd_sc_hs__dfxtp_1_5/a_731_101# 0
C156 sky130_fd_sc_hs__mux2i_1_5/a_114_74# sky130_fd_sc_hs__mux2i_1_1/a_225_74# 0
C157 sky130_fd_sc_hs__dfxtp_1_2/a_27_74# stored_values.4 0.05306f
C158 sky130_fd_sc_hs__nor2_1_3/Y stored_values.6 0
C159 sky130_fd_sc_hs__dfxtp_1_4/a_668_503# stored_values.1 0
C160 stored_values.4 count.4 0.32544f
C161 stored_values.1 stored_values.0 0.01067f
C162 stored_values.2 sky130_fd_sc_hs__dfxtp_1_0/a_27_74# 0
C163 sky130_fd_sc_hs__dfxtp_1_7/a_27_74# enable 0.00297f
C164 VPWR sky130_fd_sc_hs__mux2i_1_6/a_225_74# -0.00113f
C165 sky130_fd_sc_hs__nor2_1_7/B sky130_fd_sc_hs__nor2_1_4/B 0.01647f
C166 sky130_fd_sc_hs__dfxtp_1_4/a_1210_314# sky130_fd_sc_hs__dfxtp_1_5/a_206_368# 0
C167 sky130_fd_sc_hs__dfxtp_1_5/a_1210_314# enable 0.03173f
C168 clk sky130_fd_sc_hs__dfxtp_1_0/a_561_463# 0.00505f
C169 sky130_fd_sc_hs__dfxtp_1_0/a_206_368# enable 0.00105f
C170 stored_values.7 sky130_fd_sc_hs__dfxtp_1_1/a_668_503# 0.00105f
C171 sky130_fd_sc_hs__mux2i_1_2/a_223_368# stored_values.5 0.05403f
C172 sky130_fd_sc_hs__mux2i_1_2/a_114_74# count.5 0
C173 sky130_fd_sc_hs__dfxtp_1_4/a_1011_424# stored_values.5 0
C174 sky130_fd_sc_hs__dfxtp_1_2/a_206_368# sky130_fd_sc_hs__nor2_1_2/B 0.00216f
C175 sky130_fd_sc_hs__nor2_1_7/B sky130_fd_sc_hs__dfxtp_1_6/a_1168_124# 0
C176 sky130_fd_sc_hs__mux2i_1_5/a_426_74# enable 0
C177 clk sky130_fd_sc_hs__mux2i_1_2/a_114_74# 0
C178 sky130_fd_sc_hs__dfxtp_1_3/a_561_463# stored_values.1 0
C179 sky130_fd_sc_hs__dfxtp_1_7/a_731_101# clk 0
C180 clk sky130_fd_sc_hs__dfxtp_1_4/a_668_503# 0
C181 sky130_fd_sc_hs__mux2i_1_5/a_399_368# sky130_fd_sc_hs__nor2_1_6/a_116_368# 0
C182 sky130_fd_sc_hs__mux2i_1_5/a_114_74# sky130_fd_sc_hs__mux2i_1_1/a_114_74# 0.00347f
C183 stored_values.6 sky130_fd_sc_hs__mux2i_1_3/a_399_368# 0
C184 stored_values.7 sky130_fd_sc_hs__dfxtp_1_7/a_1011_424# 0.00117f
C185 clk stored_values.0 0.08151f
C186 sky130_fd_sc_hs__dfxtp_1_0/a_713_458# sky130_fd_sc_hs__dfxtp_1_1/a_561_463# 0
C187 sky130_fd_sc_hs__nor2_1_0/Y sky130_fd_sc_hs__nor2_1_0/a_116_368# 0
C188 clk stored_values.3 0.04854f
C189 VPWR sky130_fd_sc_hs__dfxtp_1_1/a_1011_424# -0.01265f
C190 sky130_fd_sc_hs__dfxtp_1_3/a_561_463# count.5 0
C191 sky130_fd_sc_hs__dfxtp_1_3/a_1210_314# stored_values.5 0.05404f
C192 VPWR sky130_fd_sc_hs__dfxtp_1_0/a_1118_508# -0.00128f
C193 stored_values.6 sky130_fd_sc_hs__mux2i_1_1/a_223_368# 0.05362f
C194 sky130_fd_sc_hs__dfxtp_1_4/a_713_458# sky130_fd_sc_hs__mux2i_1_5/a_399_368# 0
C195 sky130_fd_sc_hs__dfxtp_1_4/a_1210_314# sky130_fd_sc_hs__mux2i_1_5/a_114_74# 0
C196 sky130_fd_sc_hs__dfxtp_1_4/a_206_368# sky130_fd_sc_hs__mux2i_1_5/a_225_74# 0
C197 sky130_fd_sc_hs__dfxtp_1_2/a_27_74# stored_values.5 0
C198 clk sky130_fd_sc_hs__dfxtp_1_3/a_561_463# 0.00231f
C199 count.2 sky130_fd_sc_hs__nor2_1_6/B 0.05553f
C200 sky130_fd_sc_hs__nor2_1_4/a_116_368# sky130_fd_sc_hs__dfxtp_1_3/a_27_74# 0
C201 sky130_fd_sc_hs__dfxtp_1_3/a_1210_314# sky130_fd_sc_hs__dfxtp_1_7/a_206_368# 0
C202 clk sky130_fd_sc_hs__mux2i_1_0/a_114_74# 0
C203 sky130_fd_sc_hs__nor2_1_5/B sky130_fd_sc_hs__mux2i_1_1/a_399_368# 0
C204 sky130_fd_sc_hs__nor2_1_6/Y enable 0.00206f
C205 reset sky130_fd_sc_hs__mux2i_1_1/a_399_368# 0.00643f
C206 clk sky130_fd_sc_hs__dfxtp_1_1/a_27_74# 0.05906f
C207 stored_values.7 stored_values.6 0.00495f
C208 sky130_fd_sc_hs__dfxtp_1_0/a_27_74# sky130_fd_sc_hs__dfxtp_1_1/a_561_463# 0
C209 reset sky130_fd_sc_hs__nor2_1_5/B 0.15191f
C210 sky130_fd_sc_hs__nor2_1_5/a_116_368# sky130_fd_sc_hs__mux2i_1_1/a_399_368# 0
C211 sky130_fd_sc_hs__nor2_1_4/a_116_368# sky130_fd_sc_hs__nor2_1_7/B 0
C212 sky130_fd_sc_hs__dfxtp_1_7/a_1168_124# sky130_fd_sc_hs__nor2_1_3/B 0
C213 sky130_fd_sc_hs__dfxtp_1_7/a_27_74# sky130_fd_sc_hs__nor2_1_5/Y 0.13705f
C214 sky130_fd_sc_hs__nor2_1_5/a_116_368# sky130_fd_sc_hs__nor2_1_5/B 0
C215 sky130_fd_sc_hs__mux2i_1_6/a_225_74# count.1 0.00795f
C216 sky130_fd_sc_hs__nor2_1_1/Y sky130_fd_sc_hs__dfxtp_1_5/a_206_368# 0
C217 sky130_fd_sc_hs__nor2_1_1/B sky130_fd_sc_hs__dfxtp_1_5/a_561_463# 0
C218 reset sky130_fd_sc_hs__nor2_1_5/a_116_368# 0
C219 sky130_fd_sc_hs__dfxtp_1_6/a_206_368# sky130_fd_sc_hs__mux2i_1_4/a_114_74# 0
C220 VPWR count.6 0.10813f
C221 sky130_fd_sc_hs__dfxtp_1_3/a_206_368# sky130_fd_sc_hs__mux2i_1_1/a_223_368# 0
C222 sky130_fd_sc_hs__mux2i_1_2/a_114_74# sky130_fd_sc_hs__mux2i_1_6/a_114_74# 0.00347f
C223 sky130_fd_sc_hs__mux2i_1_6/a_114_74# stored_values.0 0.00122f
C224 VPWR sky130_fd_sc_hs__dfxtp_1_4/a_731_101# -0
C225 sky130_fd_sc_hs__nor2_1_7/B sky130_fd_sc_hs__dfxtp_1_6/a_206_368# 0
C226 clk sky130_fd_sc_hs__mux2i_1_6/a_426_74# 0
C227 sky130_fd_sc_hs__dfxtp_1_5/a_1168_124# sky130_fd_sc_hs__nor2_1_1/B 0
C228 sky130_fd_sc_hs__dfxtp_1_4/a_561_463# reset 0.00167f
C229 sky130_fd_sc_hs__nor2_1_3/B sky130_fd_sc_hs__dfxtp_1_1/a_206_368# 0.00172f
C230 sky130_fd_sc_hs__dfxtp_1_5/a_713_458# sky130_fd_sc_hs__dfxtp_1_5/a_561_463# 0
C231 stored_values.2 enable 0.18195f
C232 reset sky130_fd_sc_hs__dfxtp_1_6/a_731_101# 0
C233 sky130_fd_sc_hs__dfxtp_1_4/a_713_458# sky130_fd_sc_hs__dfxtp_1_3/a_27_74# 0
C234 sky130_fd_sc_hs__dfxtp_1_4/a_206_368# sky130_fd_sc_hs__dfxtp_1_3/a_206_368# 0.05719f
C235 stored_values.3 sky130_fd_sc_hs__mux2i_1_3/a_223_368# 0
C236 sky130_fd_sc_hs__nor2_1_6/Y sky130_fd_sc_hs__nor2_1_5/Y -0
C237 VPWR sky130_fd_sc_hs__nor2_1_2/Y 0.01164f
C238 sky130_fd_sc_hs__dfxtp_1_6/a_1210_314# enable 0.03165f
C239 count.2 sky130_fd_sc_hs__dfxtp_1_4/a_1011_424# 0
C240 sky130_fd_sc_hs__dfxtp_1_2/a_1168_124# sky130_fd_sc_hs__nor2_1_4/B 0
C241 sky130_fd_sc_hs__dfxtp_1_7/a_1011_424# sky130_fd_sc_hs__dfxtp_1_5/a_206_368# 0
C242 sky130_fd_sc_hs__mux2i_1_4/a_426_74# sky130_fd_sc_hs__nor2_1_0/B 0.00126f
C243 VPWR sky130_fd_sc_hs__mux2i_1_4/a_399_368# 0.07055f
C244 sky130_fd_sc_hs__dfxtp_1_4/a_713_458# sky130_fd_sc_hs__nor2_1_7/B 0
C245 sky130_fd_sc_hs__mux2i_1_3/a_114_74# sky130_fd_sc_hs__dfxtp_1_1/a_206_368# 0
C246 clk sky130_fd_sc_hs__dfxtp_1_0/a_731_101# 0
C247 enable sky130_fd_sc_hs__nor2_1_0/B 0.0115f
C248 sky130_fd_sc_hs__mux2i_1_7/a_114_74# enable 0.03194f
C249 sky130_fd_sc_hs__dfxtp_1_3/a_713_458# sky130_fd_sc_hs__mux2i_1_1/a_223_368# 0
C250 sky130_fd_sc_hs__dfxtp_1_4/a_27_74# stored_values.0 0
C251 sky130_fd_sc_hs__dfxtp_1_5/a_1210_314# sky130_fd_sc_hs__dfxtp_1_0/a_206_368# 0
C252 sky130_fd_sc_hs__nor2_1_4/Y stored_values.4 0
C253 sky130_fd_sc_hs__mux2i_1_5/a_225_74# sky130_fd_sc_hs__dfxtp_1_5/a_206_368# 0
C254 VPWR sky130_fd_sc_hs__dfxtp_1_0/a_561_463# -0.01671f
C255 sky130_fd_sc_hs__dfxtp_1_6/a_561_463# sky130_fd_sc_hs__nor2_1_0/B 0
C256 sky130_fd_sc_hs__dfxtp_1_6/a_668_503# stored_values.0 0.00135f
C257 sky130_fd_sc_hs__nor2_1_2/Y sky130_fd_sc_hs__dfxtp_1_2/a_1210_314# 0
C258 stored_values.1 sky130_fd_sc_hs__nor2_1_6/B 0
C259 sky130_fd_sc_hs__mux2i_1_7/a_399_368# stored_values.3 0.07349f
C260 VPWR sky130_fd_sc_hs__mux2i_1_2/a_114_74# 0.0082f
C261 sky130_fd_sc_hs__dfxtp_1_3/a_561_463# sky130_fd_sc_hs__dfxtp_1_4/a_27_74# 0
C262 VPWR sky130_fd_sc_hs__dfxtp_1_7/a_731_101# -0
C263 VPWR sky130_fd_sc_hs__dfxtp_1_4/a_668_503# -0
C264 VPWR stored_values.0 1.3761f
C265 sky130_fd_sc_hs__dfxtp_1_2/a_713_458# enable 0.00162f
C266 enable sky130_fd_sc_hs__dfxtp_1_1/a_561_463# 0
C267 VPWR stored_values.3 1.31138f
C268 reset sky130_fd_sc_hs__nor2_1_0/Y 0.0121f
C269 sky130_fd_sc_hs__dfxtp_1_2/a_561_463# sky130_fd_sc_hs__dfxtp_1_6/a_713_458# 0
C270 sky130_fd_sc_hs__dfxtp_1_0/a_1011_424# sky130_fd_sc_hs__dfxtp_1_1/a_206_368# 0
C271 sky130_fd_sc_hs__dfxtp_1_2/a_713_458# sky130_fd_sc_hs__dfxtp_1_6/a_561_463# 0
C272 stored_values.1 sky130_fd_sc_hs__dfxtp_1_4/a_1168_124# 0
C273 stored_values.2 sky130_fd_sc_hs__nor2_1_5/Y -0
C274 clk sky130_fd_sc_hs__nor2_1_6/B 0.14948f
C275 sky130_fd_sc_hs__dfxtp_1_0/a_1210_314# sky130_fd_sc_hs__dfxtp_1_1/a_1210_314# 0.00625f
C276 sky130_fd_sc_hs__dfxtp_1_3/a_1011_424# sky130_fd_sc_hs__dfxtp_1_4/a_1011_424# 0.00381f
C277 sky130_fd_sc_hs__dfxtp_1_2/a_1210_314# sky130_fd_sc_hs__mux2i_1_2/a_114_74# 0
C278 VPWR sky130_fd_sc_hs__dfxtp_1_3/a_561_463# -0.01604f
C279 sky130_fd_sc_hs__nor2_1_3/B sky130_fd_sc_hs__dfxtp_1_1/a_731_101# 0
C280 sky130_fd_sc_hs__nor2_1_3/Y sky130_fd_sc_hs__dfxtp_1_1/a_1011_424# 0
C281 sky130_fd_sc_hs__nor2_1_6/Y sky130_fd_sc_hs__dfxtp_1_5/a_1210_314# 0
C282 sky130_fd_sc_hs__dfxtp_1_7/a_561_463# count.6 0.00103f
C283 sky130_fd_sc_hs__dfxtp_1_7/a_1210_314# stored_values.6 0.0461f
C284 stored_values.4 enable 0.04229f
C285 sky130_fd_sc_hs__dfxtp_1_2/a_1210_314# stored_values.0 0
C286 sky130_fd_sc_hs__nor2_1_4/Y stored_values.5 0.32247f
C287 sky130_fd_sc_hs__nor2_1_7/B sky130_fd_sc_hs__nor2_1_7/Y 0.06272f
C288 VPWR sky130_fd_sc_hs__mux2i_1_0/a_114_74# 0.00347f
C289 sky130_fd_sc_hs__mux2i_1_6/a_225_74# sky130_fd_sc_hs__dfxtp_1_6/a_27_74# 0
C290 sky130_fd_sc_hs__mux2i_1_6/a_399_368# sky130_fd_sc_hs__dfxtp_1_6/a_206_368# 0
C291 sky130_fd_sc_hs__nor2_1_3/a_116_368# VPWR -0
C292 VPWR sky130_fd_sc_hs__dfxtp_1_1/a_27_74# -0.02691f
C293 sky130_fd_sc_hs__dfxtp_1_4/a_1210_314# sky130_fd_sc_hs__nor2_1_7/Y 0
C294 count.7 sky130_fd_sc_hs__dfxtp_1_1/a_561_463# 0.00105f
C295 clk sky130_fd_sc_hs__dfxtp_1_4/a_1168_124# 0
C296 reset sky130_fd_sc_hs__dfxtp_1_5/a_561_463# 0.00168f
C297 sky130_fd_sc_hs__dfxtp_1_2/a_731_101# reset 0
C298 sky130_fd_sc_hs__dfxtp_1_2/a_561_463# count.4 0
C299 sky130_fd_sc_hs__dfxtp_1_2/a_1011_424# sky130_fd_sc_hs__dfxtp_1_3/a_206_368# 0
C300 sky130_fd_sc_hs__dfxtp_1_3/a_206_368# sky130_fd_sc_hs__nor2_1_4/B 0.00181f
C301 sky130_fd_sc_hs__dfxtp_1_4/a_206_368# sky130_fd_sc_hs__mux2i_1_6/a_225_74# 0
C302 reset sky130_fd_sc_hs__dfxtp_1_7/a_668_503# 0
C303 sky130_fd_sc_hs__nor2_1_2/B sky130_fd_sc_hs__nor2_1_0/B 0.0166f
C304 stored_values.1 sky130_fd_sc_hs__dfxtp_1_6/a_713_458# 0
C305 stored_values.5 enable 0.03902f
C306 stored_values.2 sky130_fd_sc_hs__dfxtp_1_7/a_27_74# 0
C307 clk sky130_fd_sc_hs__mux2i_1_4/a_225_74# 0.00245f
C308 reset sky130_fd_sc_hs__dfxtp_1_5/a_1168_124# 0
C309 sky130_fd_sc_hs__dfxtp_1_2/a_206_368# stored_values.4 0.19216f
C310 stored_values.1 sky130_fd_sc_hs__mux2i_1_2/a_223_368# 0
C311 sky130_fd_sc_hs__dfxtp_1_4/a_1011_424# stored_values.1 0.02919f
C312 stored_values.2 sky130_fd_sc_hs__dfxtp_1_5/a_1210_314# 0.04467f
C313 stored_values.2 sky130_fd_sc_hs__dfxtp_1_0/a_206_368# 0
C314 count.1 stored_values.0 0.0037f
C315 sky130_fd_sc_hs__dfxtp_1_7/a_206_368# enable 0.003f
C316 reset sky130_fd_sc_hs__mux2i_1_5/a_399_368# 0.00101f
C317 clk sky130_fd_sc_hs__dfxtp_1_0/a_1210_314# 0.00189f
C318 sky130_fd_sc_hs__dfxtp_1_5/a_454_503# enable 0
C319 stored_values.7 sky130_fd_sc_hs__dfxtp_1_1/a_1011_424# 0.03286f
C320 clk sky130_fd_sc_hs__dfxtp_1_6/a_713_458# 0.00319f
C321 stored_values.3 sky130_fd_sc_hs__dfxtp_1_5/a_27_74# 0
C322 sky130_fd_sc_hs__dfxtp_1_2/a_713_458# sky130_fd_sc_hs__nor2_1_2/B 0
C323 sky130_fd_sc_hs__dfxtp_1_3/a_1210_314# stored_values.1 0
C324 sky130_fd_sc_hs__mux2i_1_5/a_223_368# sky130_fd_sc_hs__mux2i_1_1/a_114_74# 0
C325 sky130_fd_sc_hs__dfxtp_1_7/a_1168_124# clk 0
C326 clk sky130_fd_sc_hs__dfxtp_1_4/a_1011_424# 0.00196f
C327 clk count.0 0.09583f
C328 stored_values.1 sky130_fd_sc_hs__dfxtp_1_4/a_1118_508# 0.00265f
C329 sky130_fd_sc_hs__mux2i_1_7/a_114_74# sky130_fd_sc_hs__dfxtp_1_5/a_1210_314# 0
C330 VPWR sky130_fd_sc_hs__dfxtp_1_1/a_1118_508# -0
C331 sky130_fd_sc_hs__mux2i_1_7/a_114_74# sky130_fd_sc_hs__dfxtp_1_0/a_206_368# 0
C332 stored_values.4 sky130_fd_sc_hs__nor2_1_2/B 0.09407f
C333 VPWR sky130_fd_sc_hs__dfxtp_1_0/a_731_101# -0
C334 sky130_fd_sc_hs__dfxtp_1_3/a_1210_314# count.5 0
C335 sky130_fd_sc_hs__dfxtp_1_3/a_713_458# sky130_fd_sc_hs__nor2_1_4/B 0
C336 sky130_fd_sc_hs__dfxtp_1_3/a_454_503# stored_values.5 0.02159f
C337 stored_values.3 sky130_fd_sc_hs__dfxtp_1_5/a_1011_424# 0
C338 count.6 sky130_fd_sc_hs__mux2i_1_1/a_223_368# 0
C339 stored_values.1 sky130_fd_sc_hs__nor2_1_7/a_116_368# 0.00197f
C340 sky130_fd_sc_hs__dfxtp_1_4/a_1210_314# sky130_fd_sc_hs__mux2i_1_5/a_223_368# 0
C341 sky130_fd_sc_hs__mux2i_1_6/a_399_368# sky130_fd_sc_hs__nor2_1_7/Y 0.00537f
C342 sky130_fd_sc_hs__dfxtp_1_2/a_206_368# stored_values.5 0.0011f
C343 clk sky130_fd_sc_hs__dfxtp_1_3/a_1210_314# 0
C344 stored_values.2 sky130_fd_sc_hs__nor2_1_6/Y 0.26335f
C345 sky130_fd_sc_hs__nor2_1_3/B enable 0.01065f
C346 clk sky130_fd_sc_hs__dfxtp_1_2/a_27_74# 0.05611f
C347 clk sky130_fd_sc_hs__dfxtp_1_4/a_1118_508# 0
C348 sky130_fd_sc_hs__nor2_1_1/B sky130_fd_sc_hs__nor2_1_1/Y 0.06452f
C349 clk count.4 0
C350 sky130_fd_sc_hs__nor2_1_5/B sky130_fd_sc_hs__mux2i_1_1/a_225_74# 0.0405f
C351 reset sky130_fd_sc_hs__mux2i_1_1/a_225_74# 0.00737f
C352 sky130_fd_sc_hs__nor2_1_3/B sky130_fd_sc_hs__mux2i_1_3/a_426_74# 0
C353 clk sky130_fd_sc_hs__dfxtp_1_1/a_206_368# 0.01005f
C354 sky130_fd_sc_hs__dfxtp_1_4/a_27_74# sky130_fd_sc_hs__nor2_1_6/B 0
C355 clk sky130_fd_sc_hs__nor2_1_7/a_116_368# 0
C356 stored_values.5 sky130_fd_sc_hs__nor2_1_5/Y 0
C357 stored_values.5 sky130_fd_sc_hs__dfxtp_1_3/a_1168_124# 0
C358 sky130_fd_sc_hs__dfxtp_1_3/a_27_74# sky130_fd_sc_hs__nor2_1_5/B 0
C359 reset sky130_fd_sc_hs__dfxtp_1_3/a_27_74# 0.017f
C360 sky130_fd_sc_hs__dfxtp_1_7/a_206_368# sky130_fd_sc_hs__nor2_1_5/Y 0.06194f
C361 sky130_fd_sc_hs__mux2i_1_7/a_114_74# sky130_fd_sc_hs__nor2_1_6/Y 0
C362 reset sky130_fd_sc_hs__mux2i_1_4/a_114_74# 0.00445f
C363 VPWR sky130_fd_sc_hs__nor2_1_6/B 0
C364 sky130_fd_sc_hs__nor2_1_5/B sky130_fd_sc_hs__mux2i_1_1/a_114_74# 0.0019f
C365 sky130_fd_sc_hs__nor2_1_3/B count.7 0.06441f
C366 sky130_fd_sc_hs__dfxtp_1_6/a_206_368# sky130_fd_sc_hs__mux2i_1_4/a_223_368# 0
C367 reset sky130_fd_sc_hs__mux2i_1_1/a_114_74# 0.00838f
C368 sky130_fd_sc_hs__mux2i_1_3/a_114_74# enable 0.02161f
C369 sky130_fd_sc_hs__dfxtp_1_6/a_713_458# sky130_fd_sc_hs__mux2i_1_6/a_114_74# 0
C370 sky130_fd_sc_hs__mux2i_1_2/a_114_74# sky130_fd_sc_hs__mux2i_1_6/a_223_368# 0
C371 sky130_fd_sc_hs__mux2i_1_2/a_223_368# sky130_fd_sc_hs__mux2i_1_6/a_114_74# 0
C372 sky130_fd_sc_hs__mux2i_1_6/a_223_368# stored_values.0 0
C373 reset sky130_fd_sc_hs__nor2_1_7/B 0.14853f
C374 VPWR sky130_fd_sc_hs__dfxtp_1_4/a_1168_124# -0
C375 clk sky130_fd_sc_hs__dfxtp_1_0/a_713_458# 0.00306f
C376 sky130_fd_sc_hs__nor2_1_3/a_116_368# sky130_fd_sc_hs__nor2_1_3/Y 0
C377 count.2 enable 0.07704f
C378 sky130_fd_sc_hs__dfxtp_1_4/a_1210_314# reset 0.00259f
C379 sky130_fd_sc_hs__mux2i_1_3/a_114_74# count.7 0
C380 sky130_fd_sc_hs__nor2_1_3/B sky130_fd_sc_hs__dfxtp_1_1/a_713_458# 0
C381 sky130_fd_sc_hs__nor2_1_3/Y sky130_fd_sc_hs__dfxtp_1_1/a_27_74# 0.13505f
C382 sky130_fd_sc_hs__dfxtp_1_6/a_27_74# stored_values.0 0.05279f
C383 sky130_fd_sc_hs__dfxtp_1_4/a_713_458# sky130_fd_sc_hs__dfxtp_1_3/a_206_368# 0
C384 sky130_fd_sc_hs__dfxtp_1_4/a_561_463# sky130_fd_sc_hs__dfxtp_1_3/a_27_74# 0
C385 stored_values.3 sky130_fd_sc_hs__mux2i_1_3/a_399_368# 0
C386 VPWR sky130_fd_sc_hs__mux2i_1_0/a_399_368# 0.07287f
C387 sky130_fd_sc_hs__nor2_1_4/Y sky130_fd_sc_hs__dfxtp_1_3/a_1011_424# 0
C388 sky130_fd_sc_hs__dfxtp_1_7/a_27_74# stored_values.5 0
C389 sky130_fd_sc_hs__dfxtp_1_6/a_454_503# enable 0
C390 stored_values.2 sky130_fd_sc_hs__mux2i_1_7/a_114_74# 0.00121f
C391 sky130_fd_sc_hs__mux2i_1_7/a_223_368# enable 0.0086f
C392 sky130_fd_sc_hs__dfxtp_1_7/a_27_74# sky130_fd_sc_hs__dfxtp_1_7/a_206_368# -0
C393 clk sky130_fd_sc_hs__dfxtp_1_1/a_731_101# 0
C394 sky130_fd_sc_hs__nor2_1_3/a_116_368# sky130_fd_sc_hs__mux2i_1_3/a_399_368# 0
C395 VPWR sky130_fd_sc_hs__mux2i_1_4/a_225_74# -0.00113f
C396 sky130_fd_sc_hs__dfxtp_1_4/a_561_463# sky130_fd_sc_hs__nor2_1_7/B 0
C397 clk sky130_fd_sc_hs__dfxtp_1_0/a_1168_124# 0
C398 clk sky130_fd_sc_hs__dfxtp_1_0/a_27_74# 0.06519f
C399 sky130_fd_sc_hs__mux2i_1_3/a_223_368# sky130_fd_sc_hs__dfxtp_1_1/a_206_368# 0
C400 sky130_fd_sc_hs__nor2_1_7/B sky130_fd_sc_hs__dfxtp_1_6/a_731_101# 0
C401 sky130_fd_sc_hs__dfxtp_1_4/a_206_368# stored_values.0 0
C402 count.3 stored_values.3 0.28957f
C403 sky130_fd_sc_hs__dfxtp_1_6/a_1210_314# sky130_fd_sc_hs__nor2_1_0/B 0
C404 sky130_fd_sc_hs__dfxtp_1_6/a_1011_424# stored_values.0 0.03565f
C405 VPWR sky130_fd_sc_hs__dfxtp_1_0/a_1210_314# -0.01829f
C406 reset sky130_fd_sc_hs__mux2i_1_0/a_225_74# 0.00715f
C407 stored_values.3 stored_values.7 0.01022f
C408 sky130_fd_sc_hs__mux2i_1_3/a_114_74# sky130_fd_sc_hs__nor2_1_5/Y 0
C409 VPWR sky130_fd_sc_hs__dfxtp_1_6/a_713_458# -0.00893f
C410 sky130_fd_sc_hs__mux2i_1_7/a_225_74# stored_values.3 0.00208f
C411 VPWR sky130_fd_sc_hs__mux2i_1_2/a_223_368# -0.00575f
C412 sky130_fd_sc_hs__nor2_1_4/Y sky130_fd_sc_hs__mux2i_1_2/a_399_368# 0.00532f
C413 sky130_fd_sc_hs__dfxtp_1_3/a_1011_424# enable 0.0072f
C414 VPWR sky130_fd_sc_hs__dfxtp_1_7/a_1168_124# -0
C415 sky130_fd_sc_hs__nor2_1_6/B sky130_fd_sc_hs__dfxtp_1_5/a_27_74# 0.01251f
C416 sky130_fd_sc_hs__dfxtp_1_3/a_561_463# sky130_fd_sc_hs__dfxtp_1_4/a_206_368# 0
C417 VPWR count.0 0.10443f
C418 sky130_fd_sc_hs__dfxtp_1_3/a_713_458# sky130_fd_sc_hs__dfxtp_1_4/a_713_458# 0.00468f
C419 VPWR sky130_fd_sc_hs__dfxtp_1_4/a_1011_424# -0.01178f
C420 sky130_fd_sc_hs__dfxtp_1_2/a_561_463# enable 0.00109f
C421 sky130_fd_sc_hs__nor2_1_3/a_116_368# stored_values.7 0.00186f
C422 sky130_fd_sc_hs__nor2_1_1/Y sky130_fd_sc_hs__nor2_1_1/a_116_368# 0
C423 stored_values.7 sky130_fd_sc_hs__dfxtp_1_1/a_27_74# 0.04966f
C424 sky130_fd_sc_hs__dfxtp_1_2/a_561_463# sky130_fd_sc_hs__dfxtp_1_6/a_561_463# 0.00396f
C425 sky130_fd_sc_hs__nor2_1_3/B sky130_fd_sc_hs__dfxtp_1_7/a_27_74# 0
C426 sky130_fd_sc_hs__nor2_1_0/Y sky130_fd_sc_hs__mux2i_1_4/a_114_74# 0
C427 sky130_fd_sc_hs__dfxtp_1_4/a_27_74# sky130_fd_sc_hs__nor2_1_7/a_116_368# 0
C428 reset sky130_fd_sc_hs__nor2_1_1/Y 0.01095f
C429 VPWR sky130_fd_sc_hs__dfxtp_1_3/a_1210_314# -0.00881f
C430 sky130_fd_sc_hs__nor2_1_3/B sky130_fd_sc_hs__dfxtp_1_1/a_1168_124# 0
C431 sky130_fd_sc_hs__nor2_1_6/Y sky130_fd_sc_hs__dfxtp_1_5/a_454_503# 0.00357f
C432 sky130_fd_sc_hs__nor2_1_6/B sky130_fd_sc_hs__dfxtp_1_5/a_1011_424# 0
C433 sky130_fd_sc_hs__dfxtp_1_2/a_1210_314# sky130_fd_sc_hs__mux2i_1_2/a_223_368# 0
C434 sky130_fd_sc_hs__dfxtp_1_7/a_1210_314# count.6 0
C435 sky130_fd_sc_hs__dfxtp_1_7/a_454_503# stored_values.6 0.01662f
C436 reset sky130_fd_sc_hs__mux2i_1_6/a_399_368# 0.00101f
C437 VPWR sky130_fd_sc_hs__dfxtp_1_2/a_27_74# -0.02634f
C438 sky130_fd_sc_hs__nor2_1_4/Y count.5 0.01455f
C439 sky130_fd_sc_hs__mux2i_1_6/a_225_74# sky130_fd_sc_hs__dfxtp_1_6/a_206_368# 0
C440 VPWR sky130_fd_sc_hs__dfxtp_1_4/a_1118_508# -0.00135f
C441 VPWR count.4 0.11638f
C442 VPWR sky130_fd_sc_hs__dfxtp_1_1/a_206_368# -0.0451f
C443 stored_values.4 sky130_fd_sc_hs__dfxtp_1_6/a_1210_314# 0
C444 sky130_fd_sc_hs__dfxtp_1_4/a_454_503# sky130_fd_sc_hs__nor2_1_7/Y 0.00444f
C445 count.7 sky130_fd_sc_hs__dfxtp_1_1/a_1210_314# 0
C446 clk sky130_fd_sc_hs__nor2_1_4/Y 0.04241f
C447 VPWR sky130_fd_sc_hs__nor2_1_7/a_116_368# -0.00107f
C448 sky130_fd_sc_hs__mux2i_1_5/a_223_368# stored_values.6 0
C449 sky130_fd_sc_hs__dfxtp_1_7/a_27_74# sky130_fd_sc_hs__mux2i_1_3/a_114_74# 0
C450 stored_values.4 sky130_fd_sc_hs__nor2_1_0/B 0.00159f
C451 reset sky130_fd_sc_hs__dfxtp_1_1/a_668_503# 0
C452 sky130_fd_sc_hs__dfxtp_1_2/a_1011_424# sky130_fd_sc_hs__nor2_1_2/Y 0
C453 sky130_fd_sc_hs__dfxtp_1_2/a_1168_124# reset 0
C454 stored_values.1 enable 0.19245f
C455 sky130_fd_sc_hs__dfxtp_1_2/a_1210_314# count.4 0
C456 sky130_fd_sc_hs__dfxtp_1_7/a_1011_424# sky130_fd_sc_hs__nor2_1_5/B 0
C457 sky130_fd_sc_hs__dfxtp_1_1/a_206_368# sky130_fd_sc_hs__dfxtp_1_1/a_454_503# -0
C458 count.1 sky130_fd_sc_hs__dfxtp_1_6/a_713_458# 0
C459 stored_values.1 sky130_fd_sc_hs__dfxtp_1_6/a_561_463# 0
C460 sky130_fd_sc_hs__dfxtp_1_3/a_1011_424# sky130_fd_sc_hs__nor2_1_5/Y 0
C461 reset sky130_fd_sc_hs__dfxtp_1_7/a_1011_424# 0.00427f
C462 count.5 enable 0.00318f
C463 clk sky130_fd_sc_hs__mux2i_1_4/a_426_74# 0
C464 sky130_fd_sc_hs__dfxtp_1_2/a_713_458# stored_values.4 0.02258f
C465 stored_values.2 sky130_fd_sc_hs__dfxtp_1_5/a_454_503# 0.01636f
C466 VPWR sky130_fd_sc_hs__dfxtp_1_0/a_713_458# -0.00971f
C467 clk enable 1.16931f
C468 sky130_fd_sc_hs__dfxtp_1_7/a_713_458# enable 0.00164f
C469 sky130_fd_sc_hs__dfxtp_1_4/a_1011_424# sky130_fd_sc_hs__dfxtp_1_5/a_27_74# 0
C470 reset sky130_fd_sc_hs__mux2i_1_5/a_225_74# 0.00745f
C471 clk sky130_fd_sc_hs__mux2i_1_3/a_426_74# 0
C472 sky130_fd_sc_hs__dfxtp_1_5/a_668_503# enable 0
C473 clk sky130_fd_sc_hs__dfxtp_1_0/a_454_503# 0.00383f
C474 sky130_fd_sc_hs__dfxtp_1_2/a_206_368# sky130_fd_sc_hs__mux2i_1_2/a_399_368# 0
C475 sky130_fd_sc_hs__dfxtp_1_2/a_27_74# sky130_fd_sc_hs__mux2i_1_2/a_225_74# 0
C476 sky130_fd_sc_hs__mux2i_1_2/a_114_74# sky130_fd_sc_hs__nor2_1_4/B 0.00176f
C477 sky130_fd_sc_hs__dfxtp_1_2/a_1011_424# sky130_fd_sc_hs__mux2i_1_2/a_114_74# 0
C478 stored_values.7 sky130_fd_sc_hs__dfxtp_1_1/a_1118_508# 0.00248f
C479 clk sky130_fd_sc_hs__dfxtp_1_6/a_561_463# 0.00505f
C480 stored_values.3 sky130_fd_sc_hs__dfxtp_1_5/a_206_368# 0
C481 sky130_fd_sc_hs__dfxtp_1_2/a_561_463# sky130_fd_sc_hs__nor2_1_2/B 0
C482 stored_values.6 sky130_fd_sc_hs__mux2i_1_1/a_399_368# 0.06797f
C483 sky130_fd_sc_hs__mux2i_1_5/a_399_368# sky130_fd_sc_hs__mux2i_1_1/a_114_74# 0
C484 sky130_fd_sc_hs__mux2i_1_7/a_223_368# sky130_fd_sc_hs__dfxtp_1_5/a_1210_314# 0
C485 sky130_fd_sc_hs__nor2_1_2/a_116_368# reset 0
C486 sky130_fd_sc_hs__mux2i_1_7/a_223_368# sky130_fd_sc_hs__dfxtp_1_0/a_206_368# 0
C487 stored_values.6 sky130_fd_sc_hs__nor2_1_5/B 0.0806f
C488 sky130_fd_sc_hs__dfxtp_1_6/a_1168_124# stored_values.0 0
C489 reset stored_values.6 0.14409f
C490 clk count.7 0.00137f
C491 VPWR sky130_fd_sc_hs__dfxtp_1_1/a_731_101# -0
C492 sky130_fd_sc_hs__dfxtp_1_3/a_454_503# count.5 0
C493 sky130_fd_sc_hs__dfxtp_1_3/a_561_463# sky130_fd_sc_hs__nor2_1_4/B 0
C494 sky130_fd_sc_hs__dfxtp_1_3/a_668_503# stored_values.5 0.0012f
C495 VPWR sky130_fd_sc_hs__dfxtp_1_0/a_1168_124# -0
C496 VPWR sky130_fd_sc_hs__dfxtp_1_0/a_27_74# -0.02984f
C497 count.1 sky130_fd_sc_hs__nor2_1_7/a_116_368# 0
C498 sky130_fd_sc_hs__nor2_1_5/a_116_368# stored_values.6 0.00183f
C499 sky130_fd_sc_hs__dfxtp_1_4/a_1210_314# sky130_fd_sc_hs__mux2i_1_5/a_399_368# 0
C500 sky130_fd_sc_hs__dfxtp_1_2/a_713_458# stored_values.5 0
C501 clk sky130_fd_sc_hs__dfxtp_1_3/a_454_503# 0.00239f
C502 count.2 sky130_fd_sc_hs__nor2_1_6/Y 0.01305f
C503 sky130_fd_sc_hs__dfxtp_1_3/a_1011_424# sky130_fd_sc_hs__dfxtp_1_7/a_27_74# 0
C504 sky130_fd_sc_hs__dfxtp_1_2/a_668_503# count.4 0
C505 clk sky130_fd_sc_hs__dfxtp_1_2/a_206_368# 0.01013f
C506 sky130_fd_sc_hs__nor2_1_5/B sky130_fd_sc_hs__mux2i_1_1/a_426_74# 0.0011f
C507 clk sky130_fd_sc_hs__dfxtp_1_1/a_713_458# 0.00204f
C508 sky130_fd_sc_hs__dfxtp_1_4/a_206_368# sky130_fd_sc_hs__nor2_1_6/B 0
C509 reset sky130_fd_sc_hs__mux2i_1_1/a_426_74# 0
C510 sky130_fd_sc_hs__dfxtp_1_7/a_1210_314# sky130_fd_sc_hs__dfxtp_1_1/a_27_74# 0
C511 stored_values.4 stored_values.5 0.00539f
C512 sky130_fd_sc_hs__dfxtp_1_3/a_27_74# sky130_fd_sc_hs__mux2i_1_1/a_225_74# 0
C513 sky130_fd_sc_hs__dfxtp_1_3/a_206_368# sky130_fd_sc_hs__mux2i_1_1/a_399_368# 0
C514 sky130_fd_sc_hs__mux2i_1_7/a_223_368# sky130_fd_sc_hs__nor2_1_6/Y 0
C515 sky130_fd_sc_hs__dfxtp_1_2/a_454_503# sky130_fd_sc_hs__nor2_1_2/Y 0.00459f
C516 sky130_fd_sc_hs__dfxtp_1_3/a_206_368# sky130_fd_sc_hs__nor2_1_5/B 0
C517 clk sky130_fd_sc_hs__nor2_1_5/Y 0.04699f
C518 sky130_fd_sc_hs__dfxtp_1_7/a_713_458# sky130_fd_sc_hs__nor2_1_5/Y 0
C519 sky130_fd_sc_hs__mux2i_1_6/a_114_74# enable 0.03396f
C520 reset sky130_fd_sc_hs__dfxtp_1_3/a_206_368# 0.01226f
C521 sky130_fd_sc_hs__nor2_1_4/Y sky130_fd_sc_hs__dfxtp_1_4/a_27_74# 0
C522 clk sky130_fd_sc_hs__dfxtp_1_3/a_1168_124# 0
C523 sky130_fd_sc_hs__dfxtp_1_6/a_206_368# sky130_fd_sc_hs__mux2i_1_4/a_399_368# 0
C524 sky130_fd_sc_hs__dfxtp_1_6/a_713_458# sky130_fd_sc_hs__mux2i_1_6/a_223_368# 0
C525 sky130_fd_sc_hs__dfxtp_1_3/a_27_74# sky130_fd_sc_hs__mux2i_1_1/a_114_74# 0
C526 clk sky130_fd_sc_hs__nor2_1_2/B 0.19235f
C527 stored_values.2 count.2 0.3165f
C528 VPWR sky130_fd_sc_hs__nor2_1_4/Y 0.01177f
C529 sky130_fd_sc_hs__dfxtp_1_4/a_454_503# reset 0.00141f
C530 sky130_fd_sc_hs__mux2i_1_7/a_114_74# sky130_fd_sc_hs__mux2i_1_3/a_114_74# 0.00362f
C531 sky130_fd_sc_hs__nor2_1_3/B sky130_fd_sc_hs__dfxtp_1_1/a_561_463# 0
C532 sky130_fd_sc_hs__nor2_1_3/Y sky130_fd_sc_hs__dfxtp_1_1/a_206_368# 0.05923f
C533 sky130_fd_sc_hs__mux2i_1_3/a_223_368# count.7 0
C534 stored_values.3 sky130_fd_sc_hs__mux2i_1_3/a_225_74# 0
C535 sky130_fd_sc_hs__dfxtp_1_6/a_27_74# count.0 0
C536 sky130_fd_sc_hs__dfxtp_1_6/a_206_368# stored_values.0 0.20818f
C537 sky130_fd_sc_hs__dfxtp_1_3/a_713_458# sky130_fd_sc_hs__mux2i_1_1/a_399_368# 0
C538 sky130_fd_sc_hs__dfxtp_1_4/a_27_74# enable 0.00561f
C539 stored_values.2 sky130_fd_sc_hs__mux2i_1_7/a_223_368# 0
C540 sky130_fd_sc_hs__nor2_1_4/Y sky130_fd_sc_hs__dfxtp_1_2/a_1210_314# 0
C541 sky130_fd_sc_hs__dfxtp_1_7/a_206_368# stored_values.5 0
C542 sky130_fd_sc_hs__dfxtp_1_3/a_713_458# sky130_fd_sc_hs__nor2_1_5/B 0
C543 sky130_fd_sc_hs__dfxtp_1_3/a_713_458# reset 0.00346f
C544 stored_values.7 sky130_fd_sc_hs__dfxtp_1_0/a_1210_314# 0
C545 clk sky130_fd_sc_hs__dfxtp_1_7/a_27_74# 0.05686f
C546 sky130_fd_sc_hs__mux2i_1_7/a_399_368# enable 0.00295f
C547 clk sky130_fd_sc_hs__dfxtp_1_1/a_1168_124# 0
C548 sky130_fd_sc_hs__dfxtp_1_4/a_1210_314# sky130_fd_sc_hs__nor2_1_7/B 0
C549 clk sky130_fd_sc_hs__dfxtp_1_5/a_1210_314# 0.00195f
C550 clk sky130_fd_sc_hs__dfxtp_1_0/a_206_368# 0.02003f
C551 sky130_fd_sc_hs__mux2i_1_3/a_399_368# sky130_fd_sc_hs__dfxtp_1_1/a_206_368# 0
C552 sky130_fd_sc_hs__dfxtp_1_3/a_1210_314# sky130_fd_sc_hs__mux2i_1_1/a_223_368# 0
C553 sky130_fd_sc_hs__dfxtp_1_2/a_27_74# sky130_fd_sc_hs__dfxtp_1_6/a_27_74# 0.01235f
C554 sky130_fd_sc_hs__mux2i_1_5/a_426_74# clk 0
C555 sky130_fd_sc_hs__dfxtp_1_5/a_1011_424# sky130_fd_sc_hs__dfxtp_1_0/a_27_74# 0
C556 VPWR enable 3.45985f
C557 sky130_fd_sc_hs__dfxtp_1_6/a_454_503# sky130_fd_sc_hs__nor2_1_0/B 0
C558 sky130_fd_sc_hs__dfxtp_1_6/a_1118_508# stored_values.0 0.00395f
C559 VPWR sky130_fd_sc_hs__dfxtp_1_0/a_454_503# -0.00681f
C560 VPWR sky130_fd_sc_hs__dfxtp_1_6/a_561_463# -0.01645f
C561 sky130_fd_sc_hs__mux2i_1_3/a_223_368# sky130_fd_sc_hs__nor2_1_5/Y 0
C562 stored_values.1 sky130_fd_sc_hs__nor2_1_6/Y 0
C563 sky130_fd_sc_hs__mux2i_1_4/a_114_74# sky130_fd_sc_hs__mux2i_1_0/a_225_74# 0
C564 sky130_fd_sc_hs__nor2_1_6/B sky130_fd_sc_hs__dfxtp_1_5/a_206_368# 0.00231f
C565 sky130_fd_sc_hs__dfxtp_1_3/a_561_463# sky130_fd_sc_hs__dfxtp_1_4/a_713_458# 0
C566 sky130_fd_sc_hs__dfxtp_1_3/a_713_458# sky130_fd_sc_hs__dfxtp_1_4/a_561_463# 0
C567 sky130_fd_sc_hs__dfxtp_1_2/a_1210_314# enable 0.02348f
C568 VPWR count.7 0.10828f
C569 enable sky130_fd_sc_hs__dfxtp_1_1/a_454_503# 0
C570 sky130_fd_sc_hs__mux2i_1_4/a_399_368# sky130_fd_sc_hs__nor2_1_0/a_116_368# 0
C571 reset sky130_fd_sc_hs__mux2i_1_0/a_426_74# 0
C572 sky130_fd_sc_hs__dfxtp_1_2/a_27_74# sky130_fd_sc_hs__dfxtp_1_6/a_1011_424# 0
C573 sky130_fd_sc_hs__nor2_1_2/Y sky130_fd_sc_hs__mux2i_1_0/a_223_368# 0.00117f
C574 stored_values.7 sky130_fd_sc_hs__dfxtp_1_1/a_206_368# 0.18474f
C575 clk sky130_fd_sc_hs__nor2_1_6/Y 0.08886f
C576 sky130_fd_sc_hs__nor2_1_3/B sky130_fd_sc_hs__dfxtp_1_7/a_206_368# 0
C577 sky130_fd_sc_hs__nor2_1_0/Y sky130_fd_sc_hs__mux2i_1_4/a_223_368# 0
C578 VPWR sky130_fd_sc_hs__dfxtp_1_3/a_454_503# -0.00651f
C579 sky130_fd_sc_hs__dfxtp_1_7/a_454_503# count.6 0
C580 sky130_fd_sc_hs__dfxtp_1_7/a_668_503# stored_values.6 0
C581 reset sky130_fd_sc_hs__mux2i_1_6/a_225_74# 0.00711f
C582 VPWR sky130_fd_sc_hs__dfxtp_1_2/a_206_368# -0.04072f
C583 VPWR sky130_fd_sc_hs__dfxtp_1_1/a_713_458# -0.00885f
C584 sky130_fd_sc_hs__mux2i_1_5/a_114_74# sky130_fd_sc_hs__nor2_1_6/B 0.00243f
C585 count.7 sky130_fd_sc_hs__dfxtp_1_1/a_454_503# 0
C586 sky130_fd_sc_hs__nor2_1_7/Y stored_values.0 0
C587 sky130_fd_sc_hs__mux2i_1_2/a_225_74# enable 0.00949f
C588 sky130_fd_sc_hs__dfxtp_1_0/a_561_463# sky130_fd_sc_hs__nor2_1_1/B 0
C589 sky130_fd_sc_hs__mux2i_1_5/a_399_368# stored_values.6 0
C590 sky130_fd_sc_hs__nor2_1_0/a_116_368# stored_values.0 0.00193f
C591 sky130_fd_sc_hs__dfxtp_1_7/a_206_368# sky130_fd_sc_hs__mux2i_1_3/a_114_74# 0
C592 stored_values.2 stored_values.1 0
C593 VPWR sky130_fd_sc_hs__nor2_1_5/Y 0.01243f
C594 reset sky130_fd_sc_hs__dfxtp_1_1/a_1011_424# 0.00144f
C595 sky130_fd_sc_hs__nor2_1_7/B sky130_fd_sc_hs__mux2i_1_6/a_399_368# 0.00151f
C596 count.1 enable 0.06671f
C597 VPWR sky130_fd_sc_hs__dfxtp_1_3/a_1168_124# -0
C598 stored_values.3 sky130_fd_sc_hs__nor2_1_1/B 0.06792f
C599 sky130_fd_sc_hs__dfxtp_1_5/a_27_74# enable 0.00517f
C600 stored_values.1 sky130_fd_sc_hs__dfxtp_1_6/a_1210_314# 0
C601 count.1 sky130_fd_sc_hs__dfxtp_1_6/a_561_463# 0
C602 VPWR sky130_fd_sc_hs__nor2_1_2/B -0.00337f
C603 stored_values.2 clk 0.06316f
C604 sky130_fd_sc_hs__dfxtp_1_2/a_561_463# stored_values.4 0.05622f
C605 stored_values.2 sky130_fd_sc_hs__dfxtp_1_5/a_668_503# 0
C606 sky130_fd_sc_hs__dfxtp_1_7/a_561_463# enable 0.0011f
C607 sky130_fd_sc_hs__dfxtp_1_4/a_1011_424# sky130_fd_sc_hs__dfxtp_1_5/a_206_368# 0
C608 count.3 sky130_fd_sc_hs__dfxtp_1_0/a_27_74# 0
C609 sky130_fd_sc_hs__nor2_1_3/a_116_368# sky130_fd_sc_hs__nor2_1_1/B 0
C610 sky130_fd_sc_hs__dfxtp_1_5/a_1011_424# enable 0.00765f
C611 clk sky130_fd_sc_hs__dfxtp_1_0/a_668_503# 0
C612 stored_values.7 sky130_fd_sc_hs__dfxtp_1_1/a_731_101# 0
C613 clk sky130_fd_sc_hs__dfxtp_1_6/a_1210_314# 0.00198f
C614 sky130_fd_sc_hs__dfxtp_1_2/a_713_458# sky130_fd_sc_hs__mux2i_1_2/a_399_368# 0
C615 sky130_fd_sc_hs__dfxtp_1_2/a_206_368# sky130_fd_sc_hs__mux2i_1_2/a_225_74# 0
C616 sky130_fd_sc_hs__dfxtp_1_2/a_1011_424# sky130_fd_sc_hs__mux2i_1_2/a_223_368# 0
C617 stored_values.3 sky130_fd_sc_hs__dfxtp_1_5/a_713_458# 0
C618 sky130_fd_sc_hs__dfxtp_1_2/a_1210_314# sky130_fd_sc_hs__nor2_1_2/B 0
C619 count.6 sky130_fd_sc_hs__mux2i_1_1/a_399_368# 0.02541f
C620 stored_values.6 sky130_fd_sc_hs__mux2i_1_1/a_225_74# 0.00213f
C621 sky130_fd_sc_hs__nor2_1_3/B sky130_fd_sc_hs__mux2i_1_3/a_114_74# 0.00172f
C622 sky130_fd_sc_hs__mux2i_1_5/a_225_74# sky130_fd_sc_hs__mux2i_1_1/a_114_74# 0
C623 sky130_fd_sc_hs__mux2i_1_7/a_399_368# sky130_fd_sc_hs__dfxtp_1_5/a_1210_314# 0
C624 sky130_fd_sc_hs__mux2i_1_7/a_399_368# sky130_fd_sc_hs__dfxtp_1_0/a_206_368# 0
C625 count.6 sky130_fd_sc_hs__nor2_1_5/B 0.07278f
C626 clk sky130_fd_sc_hs__nor2_1_0/B 0.13966f
C627 clk sky130_fd_sc_hs__mux2i_1_7/a_114_74# 0
C628 reset count.6 0.3225f
C629 VPWR sky130_fd_sc_hs__dfxtp_1_7/a_27_74# -0.0276f
C630 stored_values.4 sky130_fd_sc_hs__mux2i_1_2/a_399_368# 0
C631 sky130_fd_sc_hs__dfxtp_1_3/a_27_74# stored_values.6 0
C632 VPWR sky130_fd_sc_hs__dfxtp_1_1/a_1168_124# -0
C633 VPWR sky130_fd_sc_hs__dfxtp_1_5/a_1210_314# -0.00885f
C634 VPWR sky130_fd_sc_hs__dfxtp_1_0/a_206_368# -0.06184f
C635 sky130_fd_sc_hs__dfxtp_1_3/a_668_503# count.5 0
C636 sky130_fd_sc_hs__dfxtp_1_3/a_1210_314# sky130_fd_sc_hs__nor2_1_4/B 0
C637 sky130_fd_sc_hs__dfxtp_1_3/a_1011_424# stored_values.5 0.03568f
C638 sky130_fd_sc_hs__nor2_1_6/a_116_368# sky130_fd_sc_hs__nor2_1_6/B 0
C639 sky130_fd_sc_hs__nor2_1_5/a_116_368# count.6 0
C640 stored_values.6 sky130_fd_sc_hs__mux2i_1_1/a_114_74# 0.01968f
C641 sky130_fd_sc_hs__dfxtp_1_4/a_1210_314# sky130_fd_sc_hs__mux2i_1_5/a_225_74# 0
C642 sky130_fd_sc_hs__dfxtp_1_4/a_1011_424# sky130_fd_sc_hs__mux2i_1_5/a_114_74# 0
C643 sky130_fd_sc_hs__dfxtp_1_2/a_27_74# sky130_fd_sc_hs__nor2_1_4/B 0
C644 sky130_fd_sc_hs__dfxtp_1_2/a_561_463# stored_values.5 0
C645 reset sky130_fd_sc_hs__dfxtp_1_4/a_731_101# 0
C646 sky130_fd_sc_hs__dfxtp_1_3/a_1011_424# sky130_fd_sc_hs__dfxtp_1_7/a_206_368# 0
C647 sky130_fd_sc_hs__dfxtp_1_2/a_1011_424# count.4 0
C648 clk sky130_fd_sc_hs__dfxtp_1_2/a_713_458# 0.00202f
C649 sky130_fd_sc_hs__nor2_1_4/Y sky130_fd_sc_hs__mux2i_1_1/a_223_368# 0
C650 sky130_fd_sc_hs__nor2_1_3/Y enable 0
C651 sky130_fd_sc_hs__nor2_1_5/Y sky130_fd_sc_hs__dfxtp_1_5/a_27_74# 0
C652 clk sky130_fd_sc_hs__dfxtp_1_1/a_561_463# 0.00233f
C653 sky130_fd_sc_hs__dfxtp_1_4/a_27_74# sky130_fd_sc_hs__nor2_1_6/Y 0
C654 sky130_fd_sc_hs__dfxtp_1_4/a_713_458# sky130_fd_sc_hs__nor2_1_6/B 0
C655 sky130_fd_sc_hs__dfxtp_1_7/a_1210_314# sky130_fd_sc_hs__dfxtp_1_1/a_206_368# 0
C656 sky130_fd_sc_hs__dfxtp_1_3/a_206_368# sky130_fd_sc_hs__mux2i_1_1/a_225_74# 0
C657 VPWR sky130_fd_sc_hs__dfxtp_1_7/a_1118_508# -0
C658 reset sky130_fd_sc_hs__nor2_1_2/Y 0.02924f
C659 clk stored_values.4 0.00508f
C660 sky130_fd_sc_hs__dfxtp_1_7/a_561_463# sky130_fd_sc_hs__nor2_1_5/Y 0.00361f
C661 sky130_fd_sc_hs__mux2i_1_6/a_223_368# enable 0.00856f
C662 reset sky130_fd_sc_hs__mux2i_1_4/a_399_368# 0.00101f
C663 stored_values.5 sky130_fd_sc_hs__mux2i_1_2/a_399_368# 0.0685f
C664 sky130_fd_sc_hs__dfxtp_1_3/a_27_74# sky130_fd_sc_hs__dfxtp_1_3/a_206_368# -0
C665 VPWR sky130_fd_sc_hs__nor2_1_6/Y 0.01068f
C666 sky130_fd_sc_hs__nor2_1_3/Y count.7 0.01446f
C667 sky130_fd_sc_hs__dfxtp_1_6/a_206_368# sky130_fd_sc_hs__mux2i_1_4/a_225_74# 0
C668 sky130_fd_sc_hs__dfxtp_1_6/a_1210_314# sky130_fd_sc_hs__mux2i_1_6/a_114_74# 0
C669 sky130_fd_sc_hs__dfxtp_1_3/a_206_368# sky130_fd_sc_hs__mux2i_1_1/a_114_74# 0
C670 sky130_fd_sc_hs__dfxtp_1_6/a_27_74# enable 0.00518f
C671 reset sky130_fd_sc_hs__dfxtp_1_0/a_561_463# 0.00144f
C672 sky130_fd_sc_hs__dfxtp_1_0/a_731_101# sky130_fd_sc_hs__nor2_1_1/B 0
C673 stored_values.1 stored_values.5 0.01024f
C674 sky130_fd_sc_hs__dfxtp_1_7/a_731_101# sky130_fd_sc_hs__nor2_1_5/B 0
C675 reset sky130_fd_sc_hs__mux2i_1_2/a_114_74# 0.00827f
C676 sky130_fd_sc_hs__dfxtp_1_7/a_731_101# reset 0
C677 sky130_fd_sc_hs__nor2_1_3/B sky130_fd_sc_hs__dfxtp_1_1/a_1210_314# 0
C678 sky130_fd_sc_hs__nor2_1_3/Y sky130_fd_sc_hs__dfxtp_1_1/a_713_458# 0
C679 reset stored_values.0 0.03415f
C680 stored_values.3 sky130_fd_sc_hs__nor2_1_1/a_116_368# 0.00185f
C681 stored_values.5 count.5 0.34694f
C682 sky130_fd_sc_hs__mux2i_1_3/a_399_368# count.7 0.02429f
C683 stored_values.2 sky130_fd_sc_hs__dfxtp_1_4/a_27_74# 0
C684 sky130_fd_sc_hs__dfxtp_1_7/a_27_74# sky130_fd_sc_hs__dfxtp_1_5/a_27_74# 0.01204f
C685 reset stored_values.3 0.02985f
C686 count.3 enable 0.00249f
C687 clk stored_values.5 0.00495f
C688 stored_values.7 enable 0.01908f
C689 sky130_fd_sc_hs__dfxtp_1_4/a_206_368# enable 0.00643f
C690 stored_values.2 sky130_fd_sc_hs__mux2i_1_7/a_399_368# 0
C691 sky130_fd_sc_hs__dfxtp_1_3/a_561_463# sky130_fd_sc_hs__nor2_1_5/B 0
C692 sky130_fd_sc_hs__dfxtp_1_6/a_1011_424# enable 0.00726f
C693 sky130_fd_sc_hs__dfxtp_1_3/a_561_463# reset 0.0043f
C694 clk sky130_fd_sc_hs__dfxtp_1_7/a_206_368# 0.01075f
C695 sky130_fd_sc_hs__mux2i_1_7/a_225_74# enable 0.0092f
C696 sky130_fd_sc_hs__dfxtp_1_4/a_27_74# sky130_fd_sc_hs__dfxtp_1_6/a_1210_314# 0
C697 sky130_fd_sc_hs__dfxtp_1_4/a_454_503# sky130_fd_sc_hs__nor2_1_7/B 0
C698 clk sky130_fd_sc_hs__dfxtp_1_5/a_454_503# 0.0038f
C699 VPWR stored_values.2 1.24098f
C700 reset sky130_fd_sc_hs__mux2i_1_0/a_114_74# 0.00789f
C701 sky130_fd_sc_hs__dfxtp_1_7/a_27_74# sky130_fd_sc_hs__dfxtp_1_5/a_1011_424# 0
C702 sky130_fd_sc_hs__nor2_1_3/a_116_368# reset 0
C703 sky130_fd_sc_hs__mux2i_1_3/a_225_74# sky130_fd_sc_hs__dfxtp_1_1/a_206_368# 0
C704 sky130_fd_sc_hs__dfxtp_1_2/a_454_503# count.4 0
C705 sky130_fd_sc_hs__dfxtp_1_3/a_713_458# sky130_fd_sc_hs__mux2i_1_1/a_114_74# 0
C706 reset sky130_fd_sc_hs__dfxtp_1_1/a_27_74# 0.01499f
C707 sky130_fd_sc_hs__dfxtp_1_2/a_27_74# sky130_fd_sc_hs__dfxtp_1_6/a_206_368# 0
C708 sky130_fd_sc_hs__dfxtp_1_2/a_206_368# sky130_fd_sc_hs__dfxtp_1_6/a_27_74# 0
C709 sky130_fd_sc_hs__dfxtp_1_5/a_1011_424# sky130_fd_sc_hs__dfxtp_1_0/a_206_368# 0
C710 count.3 count.7 0.00472f
C711 VPWR sky130_fd_sc_hs__dfxtp_1_0/a_668_503# -0
C712 stored_values.7 count.7 0.34279f
C713 sky130_fd_sc_hs__dfxtp_1_6/a_731_101# stored_values.0 0
C714 VPWR sky130_fd_sc_hs__dfxtp_1_6/a_1210_314# -0.00978f
C715 sky130_fd_sc_hs__mux2i_1_7/a_225_74# count.7 0.00103f
C716 sky130_fd_sc_hs__dfxtp_1_3/a_731_101# enable 0
C717 sky130_fd_sc_hs__dfxtp_1_3/a_561_463# sky130_fd_sc_hs__dfxtp_1_4/a_561_463# 0.00381f
C718 sky130_fd_sc_hs__nor2_1_6/B sky130_fd_sc_hs__dfxtp_1_5/a_713_458# 0
C719 sky130_fd_sc_hs__nor2_1_6/Y sky130_fd_sc_hs__dfxtp_1_5/a_27_74# 0.13035f
C720 VPWR sky130_fd_sc_hs__nor2_1_0/B -0.00163f
C721 VPWR sky130_fd_sc_hs__mux2i_1_7/a_114_74# 0.00808f
C722 sky130_fd_sc_hs__nor2_1_5/Y sky130_fd_sc_hs__mux2i_1_1/a_223_368# 0.00109f
C723 sky130_fd_sc_hs__nor2_1_2/Y sky130_fd_sc_hs__nor2_1_0/Y 0
C724 sky130_fd_sc_hs__dfxtp_1_2/a_206_368# sky130_fd_sc_hs__dfxtp_1_6/a_1011_424# 0
C725 stored_values.7 sky130_fd_sc_hs__dfxtp_1_1/a_713_458# 0.02092f
C726 sky130_fd_sc_hs__dfxtp_1_2/a_1210_314# sky130_fd_sc_hs__dfxtp_1_6/a_1210_314# 0.00625f
C727 sky130_fd_sc_hs__dfxtp_1_0/a_1011_424# sky130_fd_sc_hs__dfxtp_1_1/a_1210_314# 0
C728 sky130_fd_sc_hs__nor2_1_3/Y sky130_fd_sc_hs__dfxtp_1_7/a_27_74# 0
C729 sky130_fd_sc_hs__nor2_1_3/B sky130_fd_sc_hs__dfxtp_1_7/a_713_458# 0
C730 clk sky130_fd_sc_hs__nor2_1_3/B 0.19198f
C731 sky130_fd_sc_hs__nor2_1_0/Y sky130_fd_sc_hs__mux2i_1_4/a_399_368# 0.00503f
C732 VPWR sky130_fd_sc_hs__dfxtp_1_3/a_668_503# -0
C733 sky130_fd_sc_hs__nor2_1_6/B sky130_fd_sc_hs__dfxtp_1_5/a_731_101# 0
C734 sky130_fd_sc_hs__nor2_1_6/Y sky130_fd_sc_hs__dfxtp_1_5/a_1011_424# 0
C735 sky130_fd_sc_hs__dfxtp_1_7/a_668_503# count.6 0
C736 sky130_fd_sc_hs__dfxtp_1_7/a_1011_424# stored_values.6 0.03182f
C737 reset sky130_fd_sc_hs__mux2i_1_6/a_426_74# 0
C738 sky130_fd_sc_hs__dfxtp_1_2/a_1011_424# sky130_fd_sc_hs__nor2_1_4/Y 0
C739 sky130_fd_sc_hs__nor2_1_4/Y sky130_fd_sc_hs__nor2_1_4/B 0.08183f
C740 VPWR sky130_fd_sc_hs__dfxtp_1_2/a_713_458# -0.00856f
C741 VPWR sky130_fd_sc_hs__dfxtp_1_1/a_561_463# -0.01629f
C742 sky130_fd_sc_hs__dfxtp_1_4/a_1011_424# sky130_fd_sc_hs__nor2_1_7/Y 0
C743 sky130_fd_sc_hs__dfxtp_1_0/a_1210_314# sky130_fd_sc_hs__nor2_1_1/B 0
C744 sky130_fd_sc_hs__mux2i_1_2/a_426_74# enable 0
C745 sky130_fd_sc_hs__mux2i_1_5/a_399_368# count.6 0
C746 sky130_fd_sc_hs__mux2i_1_5/a_225_74# stored_values.6 0
C747 sky130_fd_sc_hs__nor2_1_0/a_116_368# count.0 0
C748 sky130_fd_sc_hs__dfxtp_1_7/a_206_368# sky130_fd_sc_hs__mux2i_1_3/a_223_368# 0
C749 sky130_fd_sc_hs__dfxtp_1_7/a_713_458# sky130_fd_sc_hs__mux2i_1_3/a_114_74# 0
C750 clk sky130_fd_sc_hs__mux2i_1_3/a_114_74# 0
C751 count.2 stored_values.1 0
C752 VPWR stored_values.4 1.24443f
C753 sky130_fd_sc_hs__nor2_1_0/Y stored_values.0 0.29076f
C754 reset sky130_fd_sc_hs__dfxtp_1_1/a_1118_508# 0
C755 sky130_fd_sc_hs__nor2_1_7/B sky130_fd_sc_hs__mux2i_1_6/a_225_74# 0.02986f
C756 stored_values.2 sky130_fd_sc_hs__dfxtp_1_5/a_27_74# 0.04837f
C757 reset sky130_fd_sc_hs__dfxtp_1_0/a_731_101# 0
C758 sky130_fd_sc_hs__dfxtp_1_5/a_206_368# enable 0.00656f
C759 count.1 sky130_fd_sc_hs__dfxtp_1_6/a_1210_314# 0
C760 count.2 clk 0.10433f
C761 sky130_fd_sc_hs__dfxtp_1_2/a_1011_424# enable 0.00656f
C762 sky130_fd_sc_hs__nor2_1_4/B enable 0.01045f
C763 stored_values.2 sky130_fd_sc_hs__dfxtp_1_7/a_561_463# 0
C764 sky130_fd_sc_hs__dfxtp_1_2/a_1210_314# stored_values.4 0.05071f
C765 sky130_fd_sc_hs__nor2_1_7/a_116_368# sky130_fd_sc_hs__nor2_1_7/Y 0
C766 stored_values.2 sky130_fd_sc_hs__dfxtp_1_5/a_1011_424# 0.03085f
C767 sky130_fd_sc_hs__dfxtp_1_7/a_1210_314# enable 0.02361f
C768 sky130_fd_sc_hs__dfxtp_1_6/a_1168_124# enable 0
C769 sky130_fd_sc_hs__mux2i_1_7/a_114_74# sky130_fd_sc_hs__dfxtp_1_5/a_27_74# 0
C770 count.3 sky130_fd_sc_hs__dfxtp_1_5/a_1210_314# 0
C771 clk sky130_fd_sc_hs__dfxtp_1_0/a_1011_424# 0.00197f
C772 stored_values.7 sky130_fd_sc_hs__dfxtp_1_7/a_27_74# 0
C773 sky130_fd_sc_hs__nor2_1_6/B sky130_fd_sc_hs__mux2i_1_1/a_399_368# 0
C774 sky130_fd_sc_hs__dfxtp_1_5/a_1118_508# enable 0
C775 stored_values.7 sky130_fd_sc_hs__dfxtp_1_1/a_1168_124# 0
C776 clk sky130_fd_sc_hs__dfxtp_1_6/a_454_503# 0.0036f
C777 sky130_fd_sc_hs__nor2_1_4/a_116_368# sky130_fd_sc_hs__nor2_1_4/Y 0
C778 stored_values.3 sky130_fd_sc_hs__dfxtp_1_5/a_561_463# 0
C779 count.6 sky130_fd_sc_hs__mux2i_1_1/a_225_74# 0.00432f
C780 VPWR stored_values.5 1.21534f
C781 sky130_fd_sc_hs__nor2_1_5/B sky130_fd_sc_hs__nor2_1_6/B 0.0172f
C782 sky130_fd_sc_hs__mux2i_1_5/a_114_74# enable 0.03763f
C783 reset sky130_fd_sc_hs__nor2_1_6/B 0.14836f
C784 sky130_fd_sc_hs__mux2i_1_7/a_225_74# sky130_fd_sc_hs__dfxtp_1_5/a_1210_314# 0
C785 sky130_fd_sc_hs__mux2i_1_7/a_225_74# sky130_fd_sc_hs__dfxtp_1_0/a_206_368# 0
C786 VPWR sky130_fd_sc_hs__dfxtp_1_7/a_206_368# -0.05026f
C787 sky130_fd_sc_hs__mux2i_1_7/a_114_74# sky130_fd_sc_hs__dfxtp_1_5/a_1011_424# 0
C788 sky130_fd_sc_hs__dfxtp_1_3/a_206_368# stored_values.6 0.00108f
C789 sky130_fd_sc_hs__dfxtp_1_7/a_1210_314# count.7 0
C790 VPWR sky130_fd_sc_hs__dfxtp_1_5/a_454_503# -0.00671f
C791 sky130_fd_sc_hs__nor2_1_5/a_116_368# sky130_fd_sc_hs__nor2_1_6/B 0
C792 sky130_fd_sc_hs__dfxtp_1_3/a_1011_424# count.5 0
C793 sky130_fd_sc_hs__dfxtp_1_3/a_454_503# sky130_fd_sc_hs__nor2_1_4/B 0
C794 sky130_fd_sc_hs__dfxtp_1_3/a_1118_508# stored_values.5 0.00256f
C795 sky130_fd_sc_hs__dfxtp_1_4/a_1011_424# sky130_fd_sc_hs__mux2i_1_5/a_223_368# 0
C796 count.6 sky130_fd_sc_hs__mux2i_1_1/a_114_74# 0
C797 sky130_fd_sc_hs__dfxtp_1_2/a_206_368# sky130_fd_sc_hs__nor2_1_4/B 0
C798 sky130_fd_sc_hs__dfxtp_1_2/a_1210_314# stored_values.5 0.00275f
C799 clk sky130_fd_sc_hs__dfxtp_1_3/a_1011_424# 0.00126f
C800 reset sky130_fd_sc_hs__dfxtp_1_4/a_1168_124# 0
C801 sky130_fd_sc_hs__dfxtp_1_2/a_1118_508# count.4 0
C802 sky130_fd_sc_hs__dfxtp_1_7/a_1118_508# stored_values.7 0
C803 clk sky130_fd_sc_hs__dfxtp_1_2/a_561_463# 0.00237f
C804 sky130_fd_sc_hs__dfxtp_1_0/a_713_458# sky130_fd_sc_hs__nor2_1_1/B 0
C805 clk sky130_fd_sc_hs__dfxtp_1_1/a_1210_314# 0
C806 sky130_fd_sc_hs__dfxtp_1_4/a_206_368# sky130_fd_sc_hs__nor2_1_6/Y 0
C807 sky130_fd_sc_hs__dfxtp_1_4/a_561_463# sky130_fd_sc_hs__nor2_1_6/B 0
C808 reset sky130_fd_sc_hs__mux2i_1_0/a_399_368# 0.00521f
C809 sky130_fd_sc_hs__dfxtp_1_2/a_668_503# stored_values.4 0.00117f
C810 stored_values.1 sky130_fd_sc_hs__mux2i_1_2/a_399_368# 0
C811 sky130_fd_sc_hs__nor2_1_4/B sky130_fd_sc_hs__dfxtp_1_3/a_1168_124# 0
C812 sky130_fd_sc_hs__nor2_1_7/B sky130_fd_sc_hs__dfxtp_1_4/a_731_101# 0
C813 sky130_fd_sc_hs__dfxtp_1_7/a_1210_314# sky130_fd_sc_hs__nor2_1_5/Y 0
C814 reset sky130_fd_sc_hs__mux2i_1_4/a_225_74# 0.00704f
C815 VPWR sky130_fd_sc_hs__nor2_1_3/B -0.00516f
C816 count.5 sky130_fd_sc_hs__mux2i_1_2/a_399_368# 0.02653f
C817 stored_values.5 sky130_fd_sc_hs__mux2i_1_2/a_225_74# 0.00228f
C818 sky130_fd_sc_hs__dfxtp_1_2/a_1011_424# sky130_fd_sc_hs__nor2_1_2/B 0
C819 sky130_fd_sc_hs__mux2i_1_3/a_225_74# enable 0.00939f
C820 sky130_fd_sc_hs__dfxtp_1_2/a_454_503# enable 0
C821 sky130_fd_sc_hs__dfxtp_1_3/a_713_458# stored_values.6 0
C822 sky130_fd_sc_hs__dfxtp_1_6/a_1210_314# sky130_fd_sc_hs__mux2i_1_6/a_223_368# 0
C823 stored_values.2 sky130_fd_sc_hs__mux2i_1_1/a_223_368# 0
C824 sky130_fd_sc_hs__dfxtp_1_0/a_1168_124# sky130_fd_sc_hs__nor2_1_1/B 0
C825 sky130_fd_sc_hs__nor2_1_1/B sky130_fd_sc_hs__dfxtp_1_0/a_27_74# 0.01403f
C826 sky130_fd_sc_hs__dfxtp_1_6/a_206_368# enable 0.00503f
C827 reset sky130_fd_sc_hs__dfxtp_1_0/a_1210_314# 0
C828 reset sky130_fd_sc_hs__dfxtp_1_6/a_713_458# 0.00188f
C829 sky130_fd_sc_hs__dfxtp_1_7/a_1168_124# sky130_fd_sc_hs__nor2_1_5/B 0
C830 sky130_fd_sc_hs__nor2_1_6/a_116_368# enable 0
C831 reset sky130_fd_sc_hs__mux2i_1_2/a_223_368# 0.00362f
C832 sky130_fd_sc_hs__dfxtp_1_7/a_1168_124# reset 0
C833 clk stored_values.1 0.05583f
C834 VPWR sky130_fd_sc_hs__mux2i_1_3/a_114_74# 0.00815f
C835 reset count.0 0.13311f
C836 sky130_fd_sc_hs__dfxtp_1_4/a_1011_424# reset 0.00242f
C837 count.3 stored_values.2 0
C838 sky130_fd_sc_hs__nor2_1_3/B sky130_fd_sc_hs__dfxtp_1_1/a_454_503# 0
C839 sky130_fd_sc_hs__mux2i_1_3/a_225_74# count.7 0.00388f
C840 sky130_fd_sc_hs__nor2_1_3/Y sky130_fd_sc_hs__dfxtp_1_1/a_561_463# 0.00311f
C841 sky130_fd_sc_hs__dfxtp_1_2/a_668_503# stored_values.5 0
C842 sky130_fd_sc_hs__dfxtp_1_6/a_27_74# sky130_fd_sc_hs__nor2_1_0/B 0.01211f
C843 count.2 sky130_fd_sc_hs__dfxtp_1_4/a_27_74# 0
C844 stored_values.2 sky130_fd_sc_hs__dfxtp_1_4/a_206_368# 0
C845 sky130_fd_sc_hs__dfxtp_1_7/a_27_74# sky130_fd_sc_hs__dfxtp_1_5/a_206_368# 0
C846 sky130_fd_sc_hs__dfxtp_1_7/a_206_368# sky130_fd_sc_hs__dfxtp_1_5/a_27_74# 0
C847 sky130_fd_sc_hs__mux2i_1_4/a_114_74# stored_values.0 0.0177f
C848 sky130_fd_sc_hs__dfxtp_1_3/a_1210_314# sky130_fd_sc_hs__mux2i_1_1/a_399_368# 0
C849 clk count.5 0.00124f
C850 sky130_fd_sc_hs__dfxtp_1_4/a_713_458# enable 0.00271f
C851 sky130_fd_sc_hs__dfxtp_1_3/a_1210_314# sky130_fd_sc_hs__nor2_1_5/B 0
C852 sky130_fd_sc_hs__dfxtp_1_3/a_1210_314# reset 0.00607f
C853 clk sky130_fd_sc_hs__dfxtp_1_7/a_713_458# 0.00211f
C854 sky130_fd_sc_hs__dfxtp_1_4/a_206_368# sky130_fd_sc_hs__dfxtp_1_6/a_1210_314# 0
C855 sky130_fd_sc_hs__mux2i_1_7/a_426_74# enable 0
C856 VPWR count.2 0.10118f
C857 clk sky130_fd_sc_hs__dfxtp_1_5/a_668_503# 0
C858 reset sky130_fd_sc_hs__dfxtp_1_2/a_27_74# 0.02076f
C859 sky130_fd_sc_hs__dfxtp_1_7/a_206_368# sky130_fd_sc_hs__dfxtp_1_5/a_1011_424# 0
C860 sky130_fd_sc_hs__nor2_1_7/B stored_values.0 0
C861 sky130_fd_sc_hs__nor2_1_4/Y sky130_fd_sc_hs__nor2_1_7/Y -0
C862 sky130_fd_sc_hs__dfxtp_1_7/a_1210_314# sky130_fd_sc_hs__dfxtp_1_5/a_1210_314# 0.00606f
C863 sky130_fd_sc_hs__dfxtp_1_2/a_454_503# sky130_fd_sc_hs__dfxtp_1_2/a_206_368# -0
C864 count.3 sky130_fd_sc_hs__mux2i_1_7/a_114_74# 0
C865 reset count.4 0.29462f
C866 reset sky130_fd_sc_hs__dfxtp_1_1/a_206_368# 0.00938f
C867 sky130_fd_sc_hs__dfxtp_1_2/a_713_458# sky130_fd_sc_hs__dfxtp_1_6/a_27_74# 0
C868 sky130_fd_sc_hs__dfxtp_1_2/a_206_368# sky130_fd_sc_hs__dfxtp_1_6/a_206_368# 0.05752f
C869 sky130_fd_sc_hs__mux2i_1_0/a_114_74# sky130_fd_sc_hs__mux2i_1_4/a_114_74# 0.00362f
C870 sky130_fd_sc_hs__dfxtp_1_6/a_1011_424# sky130_fd_sc_hs__nor2_1_0/B 0
C871 VPWR sky130_fd_sc_hs__dfxtp_1_0/a_1011_424# -0.01353f
C872 VPWR sky130_fd_sc_hs__dfxtp_1_6/a_454_503# -0.00681f
C873 VPWR sky130_fd_sc_hs__mux2i_1_7/a_223_368# -0.00695f
C874 sky130_fd_sc_hs__nor2_1_6/Y sky130_fd_sc_hs__dfxtp_1_5/a_206_368# 0.05387f
C875 sky130_fd_sc_hs__nor2_1_6/B sky130_fd_sc_hs__dfxtp_1_5/a_561_463# 0
C876 sky130_fd_sc_hs__dfxtp_1_3/a_1011_424# sky130_fd_sc_hs__dfxtp_1_4/a_27_74# 0
C877 sky130_fd_sc_hs__dfxtp_1_2/a_454_503# sky130_fd_sc_hs__nor2_1_2/B 0
C878 stored_values.7 sky130_fd_sc_hs__dfxtp_1_1/a_561_463# 0.05063f
C879 stored_values.1 sky130_fd_sc_hs__mux2i_1_6/a_114_74# 0.01932f
C880 sky130_fd_sc_hs__nor2_1_7/Y enable 0.00202f
C881 sky130_fd_sc_hs__nor2_1_3/B sky130_fd_sc_hs__dfxtp_1_7/a_561_463# 0
C882 sky130_fd_sc_hs__nor2_1_3/Y sky130_fd_sc_hs__dfxtp_1_7/a_206_368# 0
C883 VPWR sky130_fd_sc_hs__dfxtp_1_3/a_1011_424# -0.01029f
C884 sky130_fd_sc_hs__nor2_1_0/a_116_368# enable 0
C885 sky130_fd_sc_hs__nor2_1_6/B sky130_fd_sc_hs__dfxtp_1_5/a_1168_124# 0
C886 reset sky130_fd_sc_hs__dfxtp_1_0/a_713_458# 0.00146f
C887 sky130_fd_sc_hs__dfxtp_1_7/a_1011_424# count.6 0
C888 sky130_fd_sc_hs__mux2i_1_0/a_225_74# stored_values.0 0
C889 VPWR sky130_fd_sc_hs__dfxtp_1_2/a_561_463# -0.0161f
C890 stored_values.5 sky130_fd_sc_hs__mux2i_1_6/a_223_368# 0
C891 VPWR sky130_fd_sc_hs__dfxtp_1_1/a_1210_314# -0.01757f
C892 sky130_fd_sc_hs__nor2_1_1/B enable 0.01206f
C893 sky130_fd_sc_hs__dfxtp_1_6/a_713_458# sky130_fd_sc_hs__nor2_1_0/Y 0
C894 sky130_fd_sc_hs__mux2i_1_5/a_399_368# sky130_fd_sc_hs__nor2_1_6/B 0.00105f
C895 sky130_fd_sc_hs__mux2i_1_5/a_114_74# sky130_fd_sc_hs__nor2_1_6/Y 0
C896 clk sky130_fd_sc_hs__mux2i_1_6/a_114_74# 0
C897 sky130_fd_sc_hs__dfxtp_1_0/a_454_503# sky130_fd_sc_hs__nor2_1_1/B 0
C898 sky130_fd_sc_hs__dfxtp_1_0/a_561_463# sky130_fd_sc_hs__nor2_1_1/Y 0.00323f
C899 sky130_fd_sc_hs__mux2i_1_5/a_225_74# count.6 0.00106f
C900 sky130_fd_sc_hs__dfxtp_1_7/a_206_368# sky130_fd_sc_hs__mux2i_1_3/a_399_368# 0
C901 sky130_fd_sc_hs__dfxtp_1_7/a_713_458# sky130_fd_sc_hs__mux2i_1_3/a_223_368# 0
C902 sky130_fd_sc_hs__dfxtp_1_7/a_27_74# sky130_fd_sc_hs__mux2i_1_3/a_225_74# 0
C903 sky130_fd_sc_hs__nor2_1_0/Y count.0 0.01213f
C904 sky130_fd_sc_hs__dfxtp_1_0/a_27_74# sky130_fd_sc_hs__nor2_1_1/a_116_368# 0
C905 sky130_fd_sc_hs__nor2_1_7/B sky130_fd_sc_hs__mux2i_1_6/a_426_74# 0.00148f
C906 count.2 sky130_fd_sc_hs__dfxtp_1_5/a_27_74# 0
C907 stored_values.2 sky130_fd_sc_hs__dfxtp_1_5/a_206_368# 0.17886f
C908 stored_values.5 sky130_fd_sc_hs__mux2i_1_1/a_223_368# 0
C909 reset sky130_fd_sc_hs__dfxtp_1_1/a_731_101# 0
C910 reset sky130_fd_sc_hs__dfxtp_1_0/a_1168_124# 0
C911 reset sky130_fd_sc_hs__dfxtp_1_0/a_27_74# 0.00912f
C912 sky130_fd_sc_hs__mux2i_1_6/a_399_368# sky130_fd_sc_hs__mux2i_1_2/a_114_74# 0
C913 sky130_fd_sc_hs__dfxtp_1_4/a_27_74# stored_values.1 0.04828f
C914 sky130_fd_sc_hs__mux2i_1_6/a_399_368# stored_values.0 0
C915 sky130_fd_sc_hs__nor2_1_1/B count.7 0.00817f
C916 sky130_fd_sc_hs__dfxtp_1_5/a_713_458# enable 0.00271f
C917 stored_values.3 sky130_fd_sc_hs__nor2_1_1/Y 0.22893f
C918 VPWR sky130_fd_sc_hs__mux2i_1_2/a_399_368# 0.07288f
C919 stored_values.6 count.6 0.32952f
C920 sky130_fd_sc_hs__dfxtp_1_7/a_206_368# sky130_fd_sc_hs__mux2i_1_1/a_223_368# 0
C921 sky130_fd_sc_hs__nor2_1_3/B sky130_fd_sc_hs__nor2_1_3/Y 0.07832f
C922 stored_values.2 sky130_fd_sc_hs__dfxtp_1_7/a_1210_314# 0
C923 sky130_fd_sc_hs__dfxtp_1_2/a_206_368# sky130_fd_sc_hs__mux2i_1_0/a_223_368# 0
C924 stored_values.2 sky130_fd_sc_hs__dfxtp_1_5/a_1118_508# 0.00245f
C925 sky130_fd_sc_hs__dfxtp_1_7/a_454_503# enable 0
C926 sky130_fd_sc_hs__dfxtp_1_2/a_1011_424# sky130_fd_sc_hs__dfxtp_1_6/a_1210_314# 0
C927 clk sky130_fd_sc_hs__dfxtp_1_4/a_27_74# 0.0613f
C928 VPWR stored_values.1 1.51736f
C929 stored_values.7 sky130_fd_sc_hs__dfxtp_1_7/a_206_368# 0.00107f
C930 sky130_fd_sc_hs__mux2i_1_7/a_114_74# sky130_fd_sc_hs__dfxtp_1_5/a_206_368# 0
C931 sky130_fd_sc_hs__dfxtp_1_5/a_731_101# enable 0
C932 sky130_fd_sc_hs__nor2_1_6/B sky130_fd_sc_hs__mux2i_1_1/a_225_74# 0.00198f
C933 sky130_fd_sc_hs__dfxtp_1_2/a_1210_314# sky130_fd_sc_hs__mux2i_1_2/a_399_368# 0
C934 clk sky130_fd_sc_hs__dfxtp_1_6/a_668_503# 0
C935 stored_values.2 sky130_fd_sc_hs__mux2i_1_5/a_114_74# 0.01883f
C936 clk sky130_fd_sc_hs__mux2i_1_7/a_399_368# 0
C937 sky130_fd_sc_hs__nor2_1_3/B sky130_fd_sc_hs__mux2i_1_3/a_399_368# 0
C938 sky130_fd_sc_hs__nor2_1_3/Y sky130_fd_sc_hs__mux2i_1_3/a_114_74# 0
C939 VPWR count.5 0.11116f
C940 sky130_fd_sc_hs__mux2i_1_5/a_223_368# enable 0.00908f
C941 sky130_fd_sc_hs__mux2i_1_7/a_223_368# sky130_fd_sc_hs__dfxtp_1_5/a_1011_424# 0
C942 sky130_fd_sc_hs__nor2_1_2/a_116_368# sky130_fd_sc_hs__nor2_1_2/Y 0
C943 sky130_fd_sc_hs__dfxtp_1_6/a_1168_124# sky130_fd_sc_hs__nor2_1_0/B 0
C944 VPWR clk 0.5723f
C945 VPWR sky130_fd_sc_hs__dfxtp_1_7/a_713_458# -0.00859f
C946 VPWR sky130_fd_sc_hs__dfxtp_1_5/a_668_503# -0
C947 sky130_fd_sc_hs__dfxtp_1_3/a_1118_508# count.5 0
C948 sky130_fd_sc_hs__dfxtp_1_3/a_731_101# stored_values.5 0
C949 sky130_fd_sc_hs__nor2_1_6/a_116_368# sky130_fd_sc_hs__nor2_1_6/Y 0
C950 sky130_fd_sc_hs__dfxtp_1_4/a_1011_424# sky130_fd_sc_hs__mux2i_1_5/a_399_368# 0
C951 sky130_fd_sc_hs__dfxtp_1_2/a_713_458# sky130_fd_sc_hs__nor2_1_4/B 0
C952 sky130_fd_sc_hs__nor2_1_4/Y reset 0.0299f
C953 clk sky130_fd_sc_hs__dfxtp_1_2/a_1210_314# 0
C954 count.3 sky130_fd_sc_hs__nor2_1_3/B 0
C955 clk sky130_fd_sc_hs__dfxtp_1_1/a_454_503# 0.00236f
C956 sky130_fd_sc_hs__dfxtp_1_4/a_1210_314# sky130_fd_sc_hs__nor2_1_6/B 0
C957 sky130_fd_sc_hs__dfxtp_1_7/a_1011_424# sky130_fd_sc_hs__dfxtp_1_1/a_27_74# 0
C958 sky130_fd_sc_hs__nor2_1_3/B stored_values.7 0.08349f
C959 sky130_fd_sc_hs__dfxtp_1_7/a_731_101# stored_values.6 0
C960 count.1 sky130_fd_sc_hs__mux2i_1_2/a_399_368# 0
C961 stored_values.4 sky130_fd_sc_hs__nor2_1_4/B 0
C962 sky130_fd_sc_hs__dfxtp_1_2/a_1011_424# stored_values.4 0.03411f
C963 stored_values.1 sky130_fd_sc_hs__mux2i_1_2/a_225_74# 0
C964 sky130_fd_sc_hs__nor2_1_7/B sky130_fd_sc_hs__dfxtp_1_4/a_1168_124# 0
C965 sky130_fd_sc_hs__dfxtp_1_7/a_454_503# sky130_fd_sc_hs__nor2_1_5/Y 0.00432f
C966 reset sky130_fd_sc_hs__mux2i_1_4/a_426_74# 0
C967 count.5 sky130_fd_sc_hs__mux2i_1_2/a_225_74# 0.00327f
C968 stored_values.1 count.1 0.3128f
C969 sky130_fd_sc_hs__nor2_1_1/a_116_368# enable 0
C970 sky130_fd_sc_hs__nor2_1_5/B enable 0.01035f
C971 sky130_fd_sc_hs__dfxtp_1_3/a_561_463# stored_values.6 0
C972 clk sky130_fd_sc_hs__mux2i_1_2/a_225_74# 0.00189f
C973 stored_values.7 sky130_fd_sc_hs__mux2i_1_3/a_114_74# 0.0194f
C974 reset enable 0.05473f
C975 sky130_fd_sc_hs__dfxtp_1_5/a_1210_314# sky130_fd_sc_hs__nor2_1_1/B 0
C976 reset sky130_fd_sc_hs__mux2i_1_3/a_426_74# 0
C977 sky130_fd_sc_hs__nor2_1_1/B sky130_fd_sc_hs__dfxtp_1_0/a_206_368# 0.0028f
C978 stored_values.2 sky130_fd_sc_hs__nor2_1_6/a_116_368# 0.00184f
C979 reset sky130_fd_sc_hs__dfxtp_1_0/a_454_503# 0.00136f
C980 sky130_fd_sc_hs__mux2i_1_7/a_225_74# sky130_fd_sc_hs__mux2i_1_3/a_114_74# 0
C981 sky130_fd_sc_hs__nor2_1_3/a_116_368# stored_values.6 0
C982 count.1 count.5 0.00454f
C983 reset sky130_fd_sc_hs__dfxtp_1_6/a_561_463# 0.00171f
C984 stored_values.6 sky130_fd_sc_hs__dfxtp_1_1/a_27_74# 0
C985 VPWR sky130_fd_sc_hs__mux2i_1_6/a_114_74# 0.0082f
C986 clk count.1 0.1028f
C987 sky130_fd_sc_hs__mux2i_1_7/a_114_74# sky130_fd_sc_hs__mux2i_1_3/a_225_74# 0
C988 VPWR sky130_fd_sc_hs__mux2i_1_3/a_223_368# -0.00588f
C989 sky130_fd_sc_hs__nor2_1_3/Y sky130_fd_sc_hs__dfxtp_1_1/a_1210_314# 0
C990 sky130_fd_sc_hs__dfxtp_1_4/a_1011_424# sky130_fd_sc_hs__dfxtp_1_3/a_27_74# 0
C991 sky130_fd_sc_hs__dfxtp_1_3/a_206_368# sky130_fd_sc_hs__mux2i_1_2/a_114_74# 0
C992 clk sky130_fd_sc_hs__dfxtp_1_5/a_27_74# 0.06816f
C993 sky130_fd_sc_hs__dfxtp_1_2/a_1011_424# stored_values.5 0.00116f
C994 stored_values.5 sky130_fd_sc_hs__nor2_1_4/B 0.08428f
C995 reset count.7 0.32468f
C996 sky130_fd_sc_hs__dfxtp_1_6/a_206_368# sky130_fd_sc_hs__nor2_1_0/B 0.00238f
C997 count.2 sky130_fd_sc_hs__dfxtp_1_4/a_206_368# 0
C998 stored_values.2 sky130_fd_sc_hs__dfxtp_1_4/a_713_458# 0
C999 sky130_fd_sc_hs__dfxtp_1_7/a_713_458# sky130_fd_sc_hs__dfxtp_1_5/a_27_74# 0
C1000 sky130_fd_sc_hs__dfxtp_1_7/a_27_74# sky130_fd_sc_hs__dfxtp_1_5/a_713_458# 0
C1001 sky130_fd_sc_hs__dfxtp_1_7/a_206_368# sky130_fd_sc_hs__dfxtp_1_5/a_206_368# 0.05719f
C1002 sky130_fd_sc_hs__dfxtp_1_3/a_1210_314# sky130_fd_sc_hs__mux2i_1_1/a_225_74# 0
C1003 sky130_fd_sc_hs__mux2i_1_4/a_114_74# count.0 0.00145f
C1004 sky130_fd_sc_hs__mux2i_1_4/a_223_368# stored_values.0 0.05484f
C1005 sky130_fd_sc_hs__dfxtp_1_4/a_561_463# enable 0.00306f
C1006 sky130_fd_sc_hs__nor2_1_7/B sky130_fd_sc_hs__dfxtp_1_6/a_713_458# 0
C1007 sky130_fd_sc_hs__dfxtp_1_3/a_454_503# reset 0.00211f
C1008 clk sky130_fd_sc_hs__dfxtp_1_7/a_561_463# 0.00247f
C1009 sky130_fd_sc_hs__dfxtp_1_6/a_731_101# enable 0
C1010 count.3 sky130_fd_sc_hs__mux2i_1_7/a_223_368# 0
C1011 sky130_fd_sc_hs__dfxtp_1_4/a_1011_424# sky130_fd_sc_hs__nor2_1_7/B 0
C1012 clk sky130_fd_sc_hs__dfxtp_1_5/a_1011_424# 0.00204f
C1013 reset sky130_fd_sc_hs__dfxtp_1_2/a_206_368# 0.01356f
C1014 sky130_fd_sc_hs__mux2i_1_7/a_223_368# stored_values.7 0
C1015 sky130_fd_sc_hs__dfxtp_1_2/a_561_463# sky130_fd_sc_hs__dfxtp_1_6/a_27_74# 0
C1016 sky130_fd_sc_hs__dfxtp_1_3/a_1210_314# sky130_fd_sc_hs__mux2i_1_1/a_114_74# 0
C1017 sky130_fd_sc_hs__dfxtp_1_3/a_1011_424# sky130_fd_sc_hs__mux2i_1_1/a_223_368# 0
C1018 reset sky130_fd_sc_hs__dfxtp_1_1/a_713_458# 0.0025f
C1019 sky130_fd_sc_hs__nor2_1_5/Y sky130_fd_sc_hs__mux2i_1_1/a_399_368# 0.00541f
C1020 VPWR sky130_fd_sc_hs__dfxtp_1_4/a_27_74# -0.03051f
C1021 VPWR sky130_fd_sc_hs__dfxtp_1_6/a_668_503# -0
C1022 sky130_fd_sc_hs__nor2_1_5/B sky130_fd_sc_hs__nor2_1_5/Y 0.08324f
C1023 sky130_fd_sc_hs__dfxtp_1_2/a_454_503# stored_values.4 0.02002f
C1024 reset sky130_fd_sc_hs__nor2_1_5/Y 0.02758f
C1025 VPWR sky130_fd_sc_hs__mux2i_1_7/a_399_368# 0.06993f
C1026 sky130_fd_sc_hs__nor2_1_5/B sky130_fd_sc_hs__dfxtp_1_3/a_1168_124# 0
C1027 sky130_fd_sc_hs__mux2i_1_2/a_225_74# sky130_fd_sc_hs__mux2i_1_6/a_114_74# 0
C1028 sky130_fd_sc_hs__nor2_1_6/Y sky130_fd_sc_hs__dfxtp_1_5/a_713_458# 0
C1029 sky130_fd_sc_hs__dfxtp_1_3/a_1011_424# sky130_fd_sc_hs__dfxtp_1_4/a_206_368# 0
C1030 sky130_fd_sc_hs__dfxtp_1_3/a_1210_314# sky130_fd_sc_hs__dfxtp_1_4/a_1210_314# 0.00606f
C1031 reset sky130_fd_sc_hs__dfxtp_1_3/a_1168_124# 0
C1032 sky130_fd_sc_hs__nor2_1_5/a_116_368# sky130_fd_sc_hs__nor2_1_5/Y 0
C1033 sky130_fd_sc_hs__nor2_1_4/a_116_368# stored_values.5 0.00191f
C1034 reset sky130_fd_sc_hs__nor2_1_2/B 0.13891f
C1035 sky130_fd_sc_hs__nor2_1_7/B sky130_fd_sc_hs__nor2_1_7/a_116_368# 0
C1036 stored_values.7 sky130_fd_sc_hs__dfxtp_1_1/a_1210_314# 0.0488f
C1037 stored_values.1 sky130_fd_sc_hs__mux2i_1_6/a_223_368# 0.05776f
C1038 count.1 sky130_fd_sc_hs__mux2i_1_6/a_114_74# 0
C1039 clk sky130_fd_sc_hs__nor2_1_3/Y 0.04443f
C1040 sky130_fd_sc_hs__nor2_1_3/B sky130_fd_sc_hs__dfxtp_1_7/a_1210_314# 0
C1041 VPWR sky130_fd_sc_hs__dfxtp_1_3/a_1118_508# -0
C1042 sky130_fd_sc_hs__mux2i_1_0/a_225_74# count.0 0
C1043 sky130_fd_sc_hs__dfxtp_1_6/a_1210_314# sky130_fd_sc_hs__nor2_1_7/Y 0
C1044 stored_values.2 sky130_fd_sc_hs__nor2_1_1/B 0
C1045 sky130_fd_sc_hs__nor2_1_0/Y enable 0.00185f
C1046 VPWR sky130_fd_sc_hs__dfxtp_1_2/a_1210_314# -0.00874f
C1047 stored_values.1 sky130_fd_sc_hs__dfxtp_1_6/a_27_74# 0
C1048 VPWR sky130_fd_sc_hs__dfxtp_1_1/a_454_503# -0.00666f
C1049 sky130_fd_sc_hs__mux2i_1_5/a_225_74# sky130_fd_sc_hs__nor2_1_6/B 0.02709f
C1050 sky130_fd_sc_hs__mux2i_1_5/a_223_368# sky130_fd_sc_hs__nor2_1_6/Y 0
C1051 sky130_fd_sc_hs__dfxtp_1_6/a_561_463# sky130_fd_sc_hs__nor2_1_0/Y 0.00334f
C1052 sky130_fd_sc_hs__dfxtp_1_0/a_1210_314# sky130_fd_sc_hs__nor2_1_1/Y 0
C1053 sky130_fd_sc_hs__nor2_1_0/a_116_368# sky130_fd_sc_hs__nor2_1_0/B 0
C1054 sky130_fd_sc_hs__dfxtp_1_7/a_27_74# sky130_fd_sc_hs__nor2_1_5/B 0.00925f
C1055 sky130_fd_sc_hs__dfxtp_1_7/a_713_458# sky130_fd_sc_hs__mux2i_1_3/a_399_368# 0
C1056 sky130_fd_sc_hs__dfxtp_1_7/a_206_368# sky130_fd_sc_hs__mux2i_1_3/a_225_74# 0
C1057 sky130_fd_sc_hs__dfxtp_1_7/a_1210_314# sky130_fd_sc_hs__mux2i_1_3/a_114_74# 0
C1058 reset sky130_fd_sc_hs__dfxtp_1_7/a_27_74# 0.01692f
C1059 sky130_fd_sc_hs__mux2i_1_6/a_399_368# sky130_fd_sc_hs__dfxtp_1_6/a_713_458# 0
C1060 reset sky130_fd_sc_hs__dfxtp_1_1/a_1168_124# 0
C1061 clk sky130_fd_sc_hs__dfxtp_1_6/a_27_74# 0.06509f
C1062 stored_values.2 sky130_fd_sc_hs__dfxtp_1_5/a_713_458# 0.0194f
C1063 sky130_fd_sc_hs__mux2i_1_7/a_114_74# sky130_fd_sc_hs__nor2_1_1/B 0.00276f
C1064 reset sky130_fd_sc_hs__dfxtp_1_5/a_1210_314# 0.00246f
C1065 reset sky130_fd_sc_hs__dfxtp_1_0/a_206_368# 0.00397f
C1066 count.4 sky130_fd_sc_hs__mux2i_1_0/a_225_74# 0.00466f
C1067 sky130_fd_sc_hs__mux2i_1_6/a_225_74# sky130_fd_sc_hs__mux2i_1_2/a_114_74# 0
C1068 stored_values.6 sky130_fd_sc_hs__nor2_1_6/B 0.00174f
C1069 sky130_fd_sc_hs__dfxtp_1_4/a_27_74# count.1 0
C1070 sky130_fd_sc_hs__dfxtp_1_4/a_206_368# stored_values.1 0.20372f
C1071 sky130_fd_sc_hs__nor2_1_5/a_116_368# sky130_fd_sc_hs__dfxtp_1_7/a_27_74# 0
C1072 sky130_fd_sc_hs__mux2i_1_5/a_426_74# reset 0
C1073 sky130_fd_sc_hs__dfxtp_1_5/a_561_463# enable 0.00283f
C1074 VPWR sky130_fd_sc_hs__mux2i_1_2/a_225_74# -0.00113f
C1075 stored_values.1 sky130_fd_sc_hs__dfxtp_1_6/a_1011_424# 0
C1076 sky130_fd_sc_hs__dfxtp_1_2/a_731_101# enable 0
C1077 sky130_fd_sc_hs__mux2i_1_7/a_223_368# sky130_fd_sc_hs__dfxtp_1_5/a_206_368# 0
C1078 stored_values.2 sky130_fd_sc_hs__dfxtp_1_5/a_731_101# 0
C1079 count.3 clk 0.10193f
C1080 VPWR count.1 0.09278f
C1081 clk stored_values.7 0.00477f
C1082 clk sky130_fd_sc_hs__dfxtp_1_4/a_206_368# 0.01854f
C1083 sky130_fd_sc_hs__mux2i_1_7/a_114_74# sky130_fd_sc_hs__dfxtp_1_5/a_713_458# 0
C1084 stored_values.7 sky130_fd_sc_hs__dfxtp_1_7/a_713_458# 0
C1085 sky130_fd_sc_hs__dfxtp_1_5/a_1168_124# enable 0
C1086 clk sky130_fd_sc_hs__dfxtp_1_6/a_1011_424# 0.00201f
C1087 count.2 sky130_fd_sc_hs__mux2i_1_5/a_114_74# 0
C1088 stored_values.2 sky130_fd_sc_hs__mux2i_1_5/a_223_368# 0.05791f
C1089 VPWR sky130_fd_sc_hs__dfxtp_1_5/a_27_74# -0.02706f
C1090 sky130_fd_sc_hs__nor2_1_2/a_116_368# sky130_fd_sc_hs__mux2i_1_0/a_399_368# 0
C1091 sky130_fd_sc_hs__dfxtp_1_2/a_1210_314# sky130_fd_sc_hs__mux2i_1_2/a_225_74# 0
C1092 sky130_fd_sc_hs__dfxtp_1_7/a_1118_508# reset 0
C1093 clk sky130_fd_sc_hs__mux2i_1_7/a_225_74# 0.00222f
C1094 VPWR sky130_fd_sc_hs__dfxtp_1_2/a_668_503# -0
C1095 sky130_fd_sc_hs__nor2_1_3/B sky130_fd_sc_hs__mux2i_1_3/a_225_74# 0.036f
C1096 sky130_fd_sc_hs__nor2_1_3/Y sky130_fd_sc_hs__mux2i_1_3/a_223_368# 0
C1097 sky130_fd_sc_hs__nor2_1_5/B sky130_fd_sc_hs__nor2_1_6/Y 0
C1098 stored_values.4 sky130_fd_sc_hs__mux2i_1_0/a_223_368# 0.05567f
C1099 sky130_fd_sc_hs__mux2i_1_5/a_399_368# enable 0.00309f
C1100 reset sky130_fd_sc_hs__nor2_1_6/Y 0.01232f
C1101 sky130_fd_sc_hs__mux2i_1_7/a_399_368# sky130_fd_sc_hs__dfxtp_1_5/a_1011_424# 0
C1102 sky130_fd_sc_hs__mux2i_1_6/a_399_368# sky130_fd_sc_hs__nor2_1_7/a_116_368# 0
C1103 stored_values.3 sky130_fd_sc_hs__dfxtp_1_0/a_1118_508# 0.00261f
C1104 VPWR sky130_fd_sc_hs__dfxtp_1_7/a_561_463# -0.01631f
C1105 VPWR sky130_fd_sc_hs__dfxtp_1_5/a_1011_424# -0.01058f
C1106 sky130_fd_sc_hs__dfxtp_1_3/a_1011_424# sky130_fd_sc_hs__nor2_1_4/B 0
C1107 sky130_fd_sc_hs__nor2_1_0/Y sky130_fd_sc_hs__nor2_1_2/B 0
C1108 sky130_fd_sc_hs__dfxtp_1_2/a_561_463# sky130_fd_sc_hs__nor2_1_4/B 0
C1109 clk sky130_fd_sc_hs__dfxtp_1_3/a_731_101# 0
C1110 sky130_fd_sc_hs__nor2_1_4/Y sky130_fd_sc_hs__dfxtp_1_3/a_27_74# 0.13647f
C1111 sky130_fd_sc_hs__dfxtp_1_6/a_27_74# sky130_fd_sc_hs__mux2i_1_6/a_114_74# 0
C1112 sky130_fd_sc_hs__dfxtp_1_0/a_713_458# sky130_fd_sc_hs__nor2_1_1/Y 0
C1113 sky130_fd_sc_hs__nor2_1_4/Y sky130_fd_sc_hs__mux2i_1_1/a_114_74# 0
C1114 sky130_fd_sc_hs__dfxtp_1_7/a_1011_424# sky130_fd_sc_hs__dfxtp_1_1/a_206_368# 0
C1115 sky130_fd_sc_hs__dfxtp_1_7/a_1168_124# stored_values.6 0
C1116 sky130_fd_sc_hs__dfxtp_1_2/a_1118_508# stored_values.4 0.00249f
C1117 count.1 sky130_fd_sc_hs__mux2i_1_2/a_225_74# 0
C1118 stored_values.2 sky130_fd_sc_hs__mux2i_1_1/a_399_368# 0
C1119 sky130_fd_sc_hs__nor2_1_4/Y sky130_fd_sc_hs__nor2_1_7/B 0.00254f
C1120 stored_values.2 sky130_fd_sc_hs__nor2_1_1/a_116_368# 0
C1121 sky130_fd_sc_hs__mux2i_1_1/a_225_74# enable 0.00995f
C1122 stored_values.2 sky130_fd_sc_hs__nor2_1_5/B 0.00108f
C1123 stored_values.2 reset 0.03202f
C1124 sky130_fd_sc_hs__nor2_1_4/B sky130_fd_sc_hs__mux2i_1_2/a_399_368# 0
C1125 sky130_fd_sc_hs__dfxtp_1_2/a_1011_424# sky130_fd_sc_hs__mux2i_1_2/a_399_368# 0
C1126 VPWR sky130_fd_sc_hs__nor2_1_3/Y 0.01213f
C1127 sky130_fd_sc_hs__dfxtp_1_4/a_206_368# sky130_fd_sc_hs__mux2i_1_6/a_114_74# 0
C1128 sky130_fd_sc_hs__dfxtp_1_2/a_731_101# sky130_fd_sc_hs__nor2_1_2/B 0
C1129 sky130_fd_sc_hs__dfxtp_1_3/a_1210_314# stored_values.6 0.00254f
C1130 sky130_fd_sc_hs__dfxtp_1_6/a_1011_424# sky130_fd_sc_hs__mux2i_1_6/a_114_74# 0
C1131 stored_values.1 sky130_fd_sc_hs__dfxtp_1_5/a_206_368# 0
C1132 sky130_fd_sc_hs__nor2_1_2/a_116_368# sky130_fd_sc_hs__dfxtp_1_2/a_27_74# 0
C1133 clk sky130_fd_sc_hs__mux2i_1_2/a_426_74# 0
C1134 stored_values.7 sky130_fd_sc_hs__mux2i_1_3/a_223_368# 0.05302f
C1135 sky130_fd_sc_hs__nor2_1_1/Y sky130_fd_sc_hs__dfxtp_1_0/a_27_74# 0.13622f
C1136 sky130_fd_sc_hs__dfxtp_1_3/a_27_74# enable 0.00317f
C1137 count.2 sky130_fd_sc_hs__nor2_1_6/a_116_368# 0
C1138 sky130_fd_sc_hs__nor2_1_2/a_116_368# count.4 0
C1139 sky130_fd_sc_hs__mux2i_1_4/a_114_74# enable 0.03075f
C1140 reset sky130_fd_sc_hs__dfxtp_1_6/a_1210_314# 0.00259f
C1141 stored_values.1 sky130_fd_sc_hs__nor2_1_4/B 0.00112f
C1142 stored_values.6 sky130_fd_sc_hs__dfxtp_1_1/a_206_368# 0
C1143 VPWR sky130_fd_sc_hs__mux2i_1_6/a_223_368# -0.00693f
C1144 enable sky130_fd_sc_hs__mux2i_1_1/a_114_74# 0.02588f
C1145 sky130_fd_sc_hs__nor2_1_2/Y sky130_fd_sc_hs__mux2i_1_2/a_114_74# 0
C1146 sky130_fd_sc_hs__dfxtp_1_3/a_206_368# sky130_fd_sc_hs__mux2i_1_2/a_223_368# 0
C1147 VPWR sky130_fd_sc_hs__mux2i_1_3/a_399_368# 0.07233f
C1148 sky130_fd_sc_hs__nor2_1_3/Y sky130_fd_sc_hs__dfxtp_1_1/a_454_503# 0.00361f
C1149 reset sky130_fd_sc_hs__nor2_1_0/B 0.14647f
C1150 sky130_fd_sc_hs__nor2_1_2/Y stored_values.0 0
C1151 reset sky130_fd_sc_hs__mux2i_1_7/a_114_74# 0.00438f
C1152 count.5 sky130_fd_sc_hs__nor2_1_4/B 0.05774f
C1153 sky130_fd_sc_hs__dfxtp_1_2/a_1118_508# stored_values.5 0
C1154 sky130_fd_sc_hs__dfxtp_1_4/a_1011_424# sky130_fd_sc_hs__dfxtp_1_3/a_206_368# 0
C1155 sky130_fd_sc_hs__dfxtp_1_7/a_561_463# sky130_fd_sc_hs__dfxtp_1_5/a_27_74# 0
C1156 count.2 sky130_fd_sc_hs__dfxtp_1_4/a_713_458# 0
C1157 stored_values.2 sky130_fd_sc_hs__dfxtp_1_4/a_561_463# 0
C1158 sky130_fd_sc_hs__dfxtp_1_7/a_206_368# sky130_fd_sc_hs__dfxtp_1_5/a_713_458# 0
C1159 sky130_fd_sc_hs__dfxtp_1_7/a_27_74# sky130_fd_sc_hs__dfxtp_1_5/a_561_463# 0
C1160 clk sky130_fd_sc_hs__dfxtp_1_5/a_206_368# 0.02043f
C1161 sky130_fd_sc_hs__mux2i_1_4/a_223_368# count.0 0
C1162 sky130_fd_sc_hs__mux2i_1_4/a_399_368# stored_values.0 0.06699f
C1163 sky130_fd_sc_hs__nor2_1_7/B enable 0.01305f
C1164 VPWR sky130_fd_sc_hs__dfxtp_1_6/a_27_74# -0.02828f
C1165 clk sky130_fd_sc_hs__dfxtp_1_2/a_1011_424# 0.00126f
C1166 clk sky130_fd_sc_hs__nor2_1_4/B 0.18372f
C1167 sky130_fd_sc_hs__dfxtp_1_4/a_1210_314# enable 0.03358f
C1168 VPWR sky130_fd_sc_hs__mux2i_1_1/a_223_368# -0.00642f
C1169 sky130_fd_sc_hs__nor2_1_7/B sky130_fd_sc_hs__dfxtp_1_6/a_561_463# 0
C1170 stored_values.1 sky130_fd_sc_hs__mux2i_1_5/a_114_74# 0
C1171 sky130_fd_sc_hs__dfxtp_1_3/a_668_503# reset 0
C1172 clk sky130_fd_sc_hs__dfxtp_1_7/a_1210_314# 0
C1173 clk sky130_fd_sc_hs__dfxtp_1_6/a_1168_124# 0
C1174 count.3 sky130_fd_sc_hs__mux2i_1_7/a_399_368# 0.02394f
C1175 sky130_fd_sc_hs__dfxtp_1_7/a_206_368# sky130_fd_sc_hs__dfxtp_1_7/a_454_503# -0
C1176 sky130_fd_sc_hs__dfxtp_1_4/a_27_74# sky130_fd_sc_hs__dfxtp_1_6/a_1011_424# 0
C1177 sky130_fd_sc_hs__mux2i_1_7/a_399_368# stored_values.7 0
C1178 clk sky130_fd_sc_hs__dfxtp_1_5/a_1118_508# 0
C1179 sky130_fd_sc_hs__nor2_1_3/B sky130_fd_sc_hs__nor2_1_1/B 0.01724f
C1180 sky130_fd_sc_hs__nor2_1_2/Y sky130_fd_sc_hs__mux2i_1_0/a_114_74# 0
C1181 reset sky130_fd_sc_hs__dfxtp_1_2/a_713_458# 0.00346f
C1182 stored_values.3 sky130_fd_sc_hs__dfxtp_1_0/a_561_463# 0.03665f
C1183 reset sky130_fd_sc_hs__dfxtp_1_1/a_561_463# 0.00358f
C1184 count.3 VPWR 0.0918f
C1185 sky130_fd_sc_hs__nor2_1_4/a_116_368# sky130_fd_sc_hs__mux2i_1_2/a_399_368# 0
C1186 VPWR stored_values.7 1.12559f
C1187 VPWR sky130_fd_sc_hs__dfxtp_1_4/a_206_368# -0.06535f
C1188 clk sky130_fd_sc_hs__mux2i_1_5/a_114_74# 0
C1189 sky130_fd_sc_hs__dfxtp_1_6/a_731_101# sky130_fd_sc_hs__nor2_1_0/B 0
C1190 VPWR sky130_fd_sc_hs__dfxtp_1_6/a_1011_424# -0.01124f
C1191 reset stored_values.4 0.07446f
C1192 VPWR sky130_fd_sc_hs__mux2i_1_7/a_225_74# -0.00113f
C1193 sky130_fd_sc_hs__dfxtp_1_3/a_27_74# sky130_fd_sc_hs__nor2_1_5/Y 0
C1194 sky130_fd_sc_hs__nor2_1_6/Y sky130_fd_sc_hs__dfxtp_1_5/a_561_463# 0.00315f
C1195 sky130_fd_sc_hs__dfxtp_1_0/a_561_463# sky130_fd_sc_hs__dfxtp_1_1/a_27_74# 0
C1196 sky130_fd_sc_hs__mux2i_1_0/a_225_74# enable 0.00962f
C1197 sky130_fd_sc_hs__nor2_1_5/Y sky130_fd_sc_hs__mux2i_1_1/a_114_74# 0
C1198 sky130_fd_sc_hs__nor2_1_4/a_116_368# count.5 0
C1199 stored_values.7 sky130_fd_sc_hs__dfxtp_1_1/a_454_503# 0.01802f
C1200 sky130_fd_sc_hs__dfxtp_1_2/a_1210_314# sky130_fd_sc_hs__dfxtp_1_6/a_1011_424# 0
C1201 count.1 sky130_fd_sc_hs__mux2i_1_6/a_223_368# 0
C1202 VPWR sky130_fd_sc_hs__dfxtp_1_3/a_731_101# -0
C1203 stored_values.5 sky130_fd_sc_hs__mux2i_1_1/a_399_368# 0
C1204 count.1 sky130_fd_sc_hs__dfxtp_1_6/a_27_74# 0
C1205 stored_values.1 sky130_fd_sc_hs__dfxtp_1_6/a_206_368# 0
C1206 sky130_fd_sc_hs__nor2_1_1/Y enable 0
C1207 sky130_fd_sc_hs__mux2i_1_5/a_399_368# sky130_fd_sc_hs__nor2_1_6/Y 0.00518f
C1208 sky130_fd_sc_hs__nor2_1_5/B stored_values.5 0
C1209 sky130_fd_sc_hs__dfxtp_1_7/a_206_368# sky130_fd_sc_hs__mux2i_1_1/a_399_368# 0
C1210 sky130_fd_sc_hs__dfxtp_1_6/a_1210_314# sky130_fd_sc_hs__nor2_1_0/Y 0
C1211 sky130_fd_sc_hs__dfxtp_1_0/a_1011_424# sky130_fd_sc_hs__nor2_1_1/B 0
C1212 sky130_fd_sc_hs__dfxtp_1_0/a_454_503# sky130_fd_sc_hs__nor2_1_1/Y 0.00373f
C1213 sky130_fd_sc_hs__mux2i_1_6/a_399_368# enable 0.00295f
C1214 reset stored_values.5 0.15104f
C1215 sky130_fd_sc_hs__dfxtp_1_7/a_1210_314# sky130_fd_sc_hs__mux2i_1_3/a_223_368# 0
C1216 sky130_fd_sc_hs__nor2_1_3/a_116_368# sky130_fd_sc_hs__dfxtp_1_1/a_27_74# 0
C1217 clk sky130_fd_sc_hs__mux2i_1_3/a_225_74# 0.00189f
C1218 sky130_fd_sc_hs__dfxtp_1_7/a_206_368# sky130_fd_sc_hs__nor2_1_5/B 0.00188f
C1219 clk sky130_fd_sc_hs__dfxtp_1_2/a_454_503# 0.00236f
C1220 sky130_fd_sc_hs__nor2_1_5/a_116_368# stored_values.5 0
C1221 reset sky130_fd_sc_hs__dfxtp_1_7/a_206_368# 0.01207f
C1222 sky130_fd_sc_hs__nor2_1_0/Y sky130_fd_sc_hs__nor2_1_0/B 0.06141f
C1223 sky130_fd_sc_hs__dfxtp_1_2/a_206_368# sky130_fd_sc_hs__mux2i_1_0/a_225_74# 0
C1224 clk sky130_fd_sc_hs__dfxtp_1_6/a_206_368# 0.01986f
C1225 reset sky130_fd_sc_hs__dfxtp_1_5/a_454_503# 0.00141f
C1226 stored_values.2 sky130_fd_sc_hs__dfxtp_1_5/a_561_463# 0.04588f
C1227 count.6 sky130_fd_sc_hs__nor2_1_6/B 0.00777f
C1228 sky130_fd_sc_hs__dfxtp_1_4/a_713_458# stored_values.1 0.0182f
C1229 count.3 sky130_fd_sc_hs__dfxtp_1_5/a_27_74# 0
C1230 clk sky130_fd_sc_hs__nor2_1_6/a_116_368# 0
C1231 count.1 sky130_fd_sc_hs__dfxtp_1_6/a_1011_424# 0
C1232 sky130_fd_sc_hs__dfxtp_1_2/a_1168_124# enable 0
C1233 sky130_fd_sc_hs__nor2_1_6/B sky130_fd_sc_hs__dfxtp_1_4/a_731_101# 0
C1234 sky130_fd_sc_hs__mux2i_1_7/a_223_368# sky130_fd_sc_hs__dfxtp_1_5/a_713_458# 0
C1235 sky130_fd_sc_hs__mux2i_1_7/a_399_368# sky130_fd_sc_hs__dfxtp_1_5/a_206_368# 0
C1236 sky130_fd_sc_hs__mux2i_1_7/a_225_74# sky130_fd_sc_hs__dfxtp_1_5/a_27_74# 0
C1237 sky130_fd_sc_hs__dfxtp_1_0/a_1210_314# sky130_fd_sc_hs__dfxtp_1_1/a_1011_424# 0
C1238 stored_values.2 sky130_fd_sc_hs__dfxtp_1_5/a_1168_124# 0
C1239 sky130_fd_sc_hs__dfxtp_1_7/a_1011_424# enable 0.00664f
C1240 clk sky130_fd_sc_hs__dfxtp_1_4/a_713_458# 0.00291f
C1241 count.3 sky130_fd_sc_hs__dfxtp_1_5/a_1011_424# 0
C1242 stored_values.7 sky130_fd_sc_hs__dfxtp_1_7/a_561_463# 0
C1243 VPWR sky130_fd_sc_hs__dfxtp_1_5/a_206_368# -0.04615f
C1244 clk sky130_fd_sc_hs__dfxtp_1_6/a_1118_508# 0
C1245 count.2 sky130_fd_sc_hs__mux2i_1_5/a_223_368# 0
C1246 stored_values.2 sky130_fd_sc_hs__mux2i_1_5/a_399_368# 0.06886f
C1247 sky130_fd_sc_hs__nor2_1_2/B sky130_fd_sc_hs__mux2i_1_0/a_225_74# 0.03656f
C1248 clk sky130_fd_sc_hs__mux2i_1_7/a_426_74# 0
C1249 VPWR sky130_fd_sc_hs__dfxtp_1_2/a_1011_424# -0.0103f
C1250 VPWR sky130_fd_sc_hs__nor2_1_4/B -0.00548f
C1251 count.7 sky130_fd_sc_hs__dfxtp_1_1/a_668_503# 0
C1252 sky130_fd_sc_hs__nor2_1_3/Y sky130_fd_sc_hs__mux2i_1_3/a_399_368# 0.00532f
C1253 sky130_fd_sc_hs__mux2i_1_5/a_225_74# enable 0.00931f
C1254 reset sky130_fd_sc_hs__nor2_1_3/B 0.14206f
C1255 stored_values.3 sky130_fd_sc_hs__dfxtp_1_0/a_731_101# 0
C1256 sky130_fd_sc_hs__dfxtp_1_4/a_27_74# sky130_fd_sc_hs__mux2i_1_5/a_114_74# 0
C1257 VPWR sky130_fd_sc_hs__dfxtp_1_7/a_1210_314# -0.00915f
C1258 VPWR sky130_fd_sc_hs__dfxtp_1_6/a_1168_124# -0
C1259 sky130_fd_sc_hs__dfxtp_1_7/a_1011_424# count.7 0
C1260 VPWR sky130_fd_sc_hs__dfxtp_1_5/a_1118_508# -0
C1261 stored_values.1 sky130_fd_sc_hs__nor2_1_7/Y 0.24187f
C1262 stored_values.6 enable 0.04274f
C1263 sky130_fd_sc_hs__dfxtp_1_2/a_1210_314# sky130_fd_sc_hs__nor2_1_4/B 0
C1264 sky130_fd_sc_hs__nor2_1_4/Y sky130_fd_sc_hs__dfxtp_1_3/a_206_368# 0.06021f
C1265 sky130_fd_sc_hs__dfxtp_1_6/a_206_368# sky130_fd_sc_hs__mux2i_1_6/a_114_74# 0
C1266 VPWR sky130_fd_sc_hs__mux2i_1_5/a_114_74# 0.00796f
C1267 reset sky130_fd_sc_hs__mux2i_1_3/a_114_74# 0.00828f
C1268 sky130_fd_sc_hs__nor2_1_3/Y stored_values.7 0.28882f
C1269 sky130_fd_sc_hs__dfxtp_1_4/a_1210_314# sky130_fd_sc_hs__nor2_1_6/Y 0
C1270 sky130_fd_sc_hs__nor2_1_2/Y sky130_fd_sc_hs__mux2i_1_0/a_399_368# 0.00539f
C1271 sky130_fd_sc_hs__dfxtp_1_2/a_731_101# stored_values.4 0
C1272 count.2 sky130_fd_sc_hs__mux2i_1_1/a_399_368# 0
C1273 clk sky130_fd_sc_hs__nor2_1_7/Y 0.09924f
C1274 stored_values.2 sky130_fd_sc_hs__mux2i_1_1/a_225_74# 0
C1275 clk sky130_fd_sc_hs__nor2_1_0/a_116_368# 0
C1276 stored_values.6 count.7 0
C1277 sky130_fd_sc_hs__mux2i_1_1/a_426_74# enable 0
C1278 count.2 sky130_fd_sc_hs__nor2_1_5/B 0
C1279 sky130_fd_sc_hs__dfxtp_1_7/a_1011_424# sky130_fd_sc_hs__nor2_1_5/Y 0
C1280 count.2 reset 0.15225f
C1281 sky130_fd_sc_hs__dfxtp_1_4/a_206_368# sky130_fd_sc_hs__mux2i_1_6/a_223_368# 0
C1282 sky130_fd_sc_hs__nor2_1_4/B sky130_fd_sc_hs__mux2i_1_2/a_225_74# 0.03749f
C1283 clk sky130_fd_sc_hs__nor2_1_1/B 0.15891f
C1284 sky130_fd_sc_hs__dfxtp_1_2/a_1168_124# sky130_fd_sc_hs__nor2_1_2/B 0
C1285 VPWR sky130_fd_sc_hs__nor2_1_4/a_116_368# -0
C1286 sky130_fd_sc_hs__dfxtp_1_6/a_1011_424# sky130_fd_sc_hs__mux2i_1_6/a_223_368# 0
C1287 sky130_fd_sc_hs__dfxtp_1_3/a_1210_314# count.6 0
C1288 stored_values.7 sky130_fd_sc_hs__mux2i_1_3/a_399_368# 0.06524f
C1289 sky130_fd_sc_hs__dfxtp_1_5/a_1210_314# sky130_fd_sc_hs__nor2_1_1/Y 0
C1290 sky130_fd_sc_hs__nor2_1_1/Y sky130_fd_sc_hs__dfxtp_1_0/a_206_368# 0.06328f
C1291 sky130_fd_sc_hs__dfxtp_1_3/a_206_368# enable 0.0032f
C1292 sky130_fd_sc_hs__mux2i_1_4/a_223_368# enable 0.0083f
C1293 reset sky130_fd_sc_hs__dfxtp_1_0/a_1011_424# 0
C1294 reset sky130_fd_sc_hs__dfxtp_1_6/a_454_503# 0.00144f
C1295 count.1 sky130_fd_sc_hs__nor2_1_4/B 0
C1296 sky130_fd_sc_hs__nor2_1_4/Y sky130_fd_sc_hs__dfxtp_1_3/a_713_458# 0
C1297 sky130_fd_sc_hs__nor2_1_2/Y sky130_fd_sc_hs__mux2i_1_2/a_223_368# 0
C1298 VPWR sky130_fd_sc_hs__mux2i_1_3/a_225_74# -0.00111f
C1299 clk sky130_fd_sc_hs__dfxtp_1_5/a_713_458# 0.00308f
C1300 VPWR sky130_fd_sc_hs__dfxtp_1_2/a_454_503# -0.00657f
C1301 sky130_fd_sc_hs__dfxtp_1_7/a_561_463# sky130_fd_sc_hs__dfxtp_1_5/a_206_368# 0
C1302 count.2 sky130_fd_sc_hs__dfxtp_1_4/a_561_463# 0
C1303 stored_values.2 sky130_fd_sc_hs__dfxtp_1_4/a_1210_314# 0
C1304 sky130_fd_sc_hs__dfxtp_1_7/a_713_458# sky130_fd_sc_hs__dfxtp_1_5/a_713_458# 0.00468f
C1305 sky130_fd_sc_hs__dfxtp_1_3/a_1011_424# sky130_fd_sc_hs__mux2i_1_1/a_399_368# 0
C1306 stored_values.6 sky130_fd_sc_hs__nor2_1_5/Y 0.26204f
C1307 sky130_fd_sc_hs__mux2i_1_4/a_225_74# stored_values.0 0.00212f
C1308 sky130_fd_sc_hs__mux2i_1_4/a_399_368# count.0 0.02779f
C1309 sky130_fd_sc_hs__mux2i_1_4/a_114_74# sky130_fd_sc_hs__nor2_1_0/B 0.00233f
C1310 VPWR sky130_fd_sc_hs__dfxtp_1_6/a_206_368# -0.05317f
C1311 sky130_fd_sc_hs__nor2_1_7/B sky130_fd_sc_hs__dfxtp_1_6/a_1210_314# 0
C1312 sky130_fd_sc_hs__dfxtp_1_4/a_454_503# enable 0
C1313 stored_values.1 sky130_fd_sc_hs__mux2i_1_5/a_223_368# 0
C1314 sky130_fd_sc_hs__dfxtp_1_3/a_1011_424# sky130_fd_sc_hs__nor2_1_5/B 0
C1315 VPWR sky130_fd_sc_hs__nor2_1_6/a_116_368# -0
C1316 sky130_fd_sc_hs__dfxtp_1_0/a_27_74# sky130_fd_sc_hs__dfxtp_1_1/a_1011_424# 0
C1317 sky130_fd_sc_hs__nor2_1_2/a_116_368# sky130_fd_sc_hs__nor2_1_2/B 0
C1318 sky130_fd_sc_hs__dfxtp_1_3/a_1011_424# reset 0.00421f
C1319 clk sky130_fd_sc_hs__dfxtp_1_7/a_454_503# 0.00252f
C1320 sky130_fd_sc_hs__dfxtp_1_4/a_206_368# sky130_fd_sc_hs__dfxtp_1_6/a_1011_424# 0
C1321 count.3 sky130_fd_sc_hs__mux2i_1_7/a_225_74# 0.00835f
C1322 sky130_fd_sc_hs__dfxtp_1_3/a_454_503# sky130_fd_sc_hs__dfxtp_1_3/a_206_368# -0
C1323 sky130_fd_sc_hs__dfxtp_1_6/a_713_458# stored_values.0 0.02246f
C1324 clk sky130_fd_sc_hs__dfxtp_1_5/a_731_101# 0
C1325 sky130_fd_sc_hs__nor2_1_2/Y sky130_fd_sc_hs__dfxtp_1_2/a_27_74# 0.13413f
C1326 reset sky130_fd_sc_hs__dfxtp_1_2/a_561_463# 0.00458f
C1327 sky130_fd_sc_hs__mux2i_1_7/a_225_74# stored_values.7 0
C1328 sky130_fd_sc_hs__nor2_1_7/Y sky130_fd_sc_hs__mux2i_1_6/a_114_74# 0
C1329 sky130_fd_sc_hs__dfxtp_1_7/a_1011_424# sky130_fd_sc_hs__dfxtp_1_5/a_1210_314# 0
C1330 sky130_fd_sc_hs__dfxtp_1_7/a_1210_314# sky130_fd_sc_hs__dfxtp_1_5/a_1011_424# 0
C1331 stored_values.3 sky130_fd_sc_hs__dfxtp_1_0/a_1210_314# 0.03947f
C1332 sky130_fd_sc_hs__nor2_1_2/Y count.4 0.01468f
C1333 reset sky130_fd_sc_hs__dfxtp_1_1/a_1210_314# 0.00112f
C1334 sky130_fd_sc_hs__mux2i_1_0/a_114_74# sky130_fd_sc_hs__mux2i_1_4/a_225_74# 0
C1335 sky130_fd_sc_hs__dfxtp_1_3/a_713_458# enable 0.00178f
C1336 stored_values.0 count.0 0.16836f
C1337 VPWR sky130_fd_sc_hs__dfxtp_1_4/a_713_458# -0.0099f
C1338 VPWR sky130_fd_sc_hs__dfxtp_1_6/a_1118_508# -0
C1339 sky130_fd_sc_hs__dfxtp_1_3/a_206_368# sky130_fd_sc_hs__nor2_1_5/Y 0
C1340 sky130_fd_sc_hs__dfxtp_1_2/a_27_74# sky130_fd_sc_hs__mux2i_1_2/a_114_74# 0
C1341 reset sky130_fd_sc_hs__mux2i_1_2/a_399_368# 0.00533f
C1342 sky130_fd_sc_hs__dfxtp_1_7/a_27_74# stored_values.6 0.04981f
C1343 stored_values.6 sky130_fd_sc_hs__dfxtp_1_5/a_1210_314# 0
C1344 sky130_fd_sc_hs__nor2_1_3/Y sky130_fd_sc_hs__dfxtp_1_7/a_1210_314# 0
C1345 sky130_fd_sc_hs__dfxtp_1_4/a_27_74# sky130_fd_sc_hs__nor2_1_7/Y 0.1385f
C1346 sky130_fd_sc_hs__nor2_1_7/a_116_368# stored_values.0 0
C1347 reset stored_values.1 0.03219f
C1348 stored_values.2 sky130_fd_sc_hs__nor2_1_1/Y 0
C1349 sky130_fd_sc_hs__mux2i_1_0/a_225_74# sky130_fd_sc_hs__nor2_1_0/B 0.00188f
C1350 count.1 sky130_fd_sc_hs__dfxtp_1_6/a_206_368# 0
C1351 enable sky130_fd_sc_hs__mux2i_1_0/a_426_74# 0
C1352 sky130_fd_sc_hs__dfxtp_1_6/a_454_503# sky130_fd_sc_hs__nor2_1_0/Y 0.00392f
C1353 sky130_fd_sc_hs__dfxtp_1_7/a_206_368# sky130_fd_sc_hs__mux2i_1_1/a_225_74# 0
C1354 sky130_fd_sc_hs__mux2i_1_6/a_225_74# enable 0.00931f
C1355 VPWR sky130_fd_sc_hs__nor2_1_7/Y 0.00955f
C1356 reset count.5 0.34251f
C1357 clk sky130_fd_sc_hs__nor2_1_1/a_116_368# 0
C1358 sky130_fd_sc_hs__mux2i_1_0/a_114_74# count.4 0
C1359 clk sky130_fd_sc_hs__nor2_1_5/B 0.20351f
C1360 VPWR sky130_fd_sc_hs__nor2_1_0/a_116_368# -0
C1361 sky130_fd_sc_hs__dfxtp_1_3/a_27_74# stored_values.5 0.05382f
C1362 sky130_fd_sc_hs__dfxtp_1_7/a_713_458# sky130_fd_sc_hs__nor2_1_5/B 0
C1363 sky130_fd_sc_hs__dfxtp_1_7/a_1210_314# sky130_fd_sc_hs__mux2i_1_3/a_399_368# 0
C1364 sky130_fd_sc_hs__dfxtp_1_7/a_1118_508# stored_values.6 0.00255f
C1365 sky130_fd_sc_hs__dfxtp_1_2/a_1011_424# sky130_fd_sc_hs__dfxtp_1_6/a_27_74# 0
C1366 sky130_fd_sc_hs__nor2_1_6/a_116_368# sky130_fd_sc_hs__dfxtp_1_5/a_27_74# 0
C1367 sky130_fd_sc_hs__mux2i_1_7/a_399_368# sky130_fd_sc_hs__nor2_1_1/B 0.00149f
C1368 reset sky130_fd_sc_hs__dfxtp_1_7/a_713_458# 0.00358f
C1369 sky130_fd_sc_hs__mux2i_1_6/a_399_368# sky130_fd_sc_hs__dfxtp_1_6/a_1210_314# 0
C1370 clk reset 0.19531f
C1371 VPWR sky130_fd_sc_hs__mux2i_1_0/a_223_368# -0.00513f
C1372 stored_values.5 sky130_fd_sc_hs__mux2i_1_1/a_114_74# 0.00136f
C1373 sky130_fd_sc_hs__mux2i_1_7/a_114_74# sky130_fd_sc_hs__nor2_1_1/Y 0
C1374 sky130_fd_sc_hs__dfxtp_1_4/a_561_463# stored_values.1 0.03883f
C1375 VPWR sky130_fd_sc_hs__nor2_1_1/B -0.00144f
C1376 count.3 sky130_fd_sc_hs__dfxtp_1_5/a_206_368# 0
C1377 sky130_fd_sc_hs__dfxtp_1_7/a_206_368# sky130_fd_sc_hs__mux2i_1_1/a_114_74# 0
C1378 stored_values.3 sky130_fd_sc_hs__dfxtp_1_0/a_713_458# 0.01759f
C1379 sky130_fd_sc_hs__nor2_1_7/B stored_values.5 0.00261f
C1380 stored_values.4 sky130_fd_sc_hs__mux2i_1_0/a_225_74# 0.00235f
C1381 sky130_fd_sc_hs__dfxtp_1_4/a_1210_314# stored_values.5 0
C1382 sky130_fd_sc_hs__nor2_1_6/B sky130_fd_sc_hs__dfxtp_1_4/a_1168_124# 0
C1383 sky130_fd_sc_hs__mux2i_1_7/a_225_74# sky130_fd_sc_hs__dfxtp_1_5/a_206_368# 0
C1384 sky130_fd_sc_hs__mux2i_1_7/a_399_368# sky130_fd_sc_hs__dfxtp_1_5/a_713_458# 0
C1385 sky130_fd_sc_hs__mux2i_1_5/a_114_74# sky130_fd_sc_hs__mux2i_1_1/a_223_368# 0
C1386 sky130_fd_sc_hs__dfxtp_1_2/a_1011_424# sky130_fd_sc_hs__dfxtp_1_6/a_1011_424# 0.00396f
C1387 clk sky130_fd_sc_hs__dfxtp_1_4/a_561_463# 0.00511f
C1388 stored_values.7 sky130_fd_sc_hs__dfxtp_1_7/a_1210_314# 0.00281f
C1389 VPWR sky130_fd_sc_hs__dfxtp_1_5/a_713_458# -0.00856f
C1390 clk sky130_fd_sc_hs__dfxtp_1_6/a_731_101# 0
C1391 stored_values.2 sky130_fd_sc_hs__mux2i_1_5/a_225_74# 0.00206f
C1392 count.2 sky130_fd_sc_hs__mux2i_1_5/a_399_368# 0.02517f
C1393 sky130_fd_sc_hs__dfxtp_1_0/a_713_458# sky130_fd_sc_hs__dfxtp_1_1/a_27_74# 0
C1394 VPWR sky130_fd_sc_hs__dfxtp_1_2/a_1118_508# -0
C1395 count.7 sky130_fd_sc_hs__dfxtp_1_1/a_1011_424# 0
C1396 stored_values.3 sky130_fd_sc_hs__dfxtp_1_0/a_1168_124# 0
C1397 stored_values.3 sky130_fd_sc_hs__dfxtp_1_0/a_27_74# 0.04536f
C1398 sky130_fd_sc_hs__dfxtp_1_4/a_206_368# sky130_fd_sc_hs__mux2i_1_5/a_114_74# 0
C1399 VPWR sky130_fd_sc_hs__dfxtp_1_7/a_454_503# -0.00681f
C1400 VPWR sky130_fd_sc_hs__dfxtp_1_5/a_731_101# -0
C1401 stored_values.2 stored_values.6 0.00985f
C1402 sky130_fd_sc_hs__dfxtp_1_3/a_731_101# sky130_fd_sc_hs__nor2_1_4/B 0
C1403 count.1 sky130_fd_sc_hs__nor2_1_7/Y 0.01276f
C1404 sky130_fd_sc_hs__nor2_1_2/B sky130_fd_sc_hs__mux2i_1_0/a_426_74# 0
C1405 count.6 enable 0.00374f
C1406 reset sky130_fd_sc_hs__mux2i_1_6/a_114_74# 0.00438f
C1407 VPWR sky130_fd_sc_hs__mux2i_1_5/a_223_368# -0.00659f
C1408 sky130_fd_sc_hs__dfxtp_1_6/a_206_368# sky130_fd_sc_hs__mux2i_1_6/a_223_368# 0
C1409 sky130_fd_sc_hs__dfxtp_1_0/a_27_74# sky130_fd_sc_hs__dfxtp_1_1/a_27_74# 0.01235f
C1410 reset sky130_fd_sc_hs__mux2i_1_3/a_223_368# 0.00394f
C1411 sky130_fd_sc_hs__dfxtp_1_4/a_1011_424# sky130_fd_sc_hs__nor2_1_6/B 0
C1412 sky130_fd_sc_hs__dfxtp_1_4/a_731_101# enable 0
C1413 sky130_fd_sc_hs__nor2_1_2/a_116_368# sky130_fd_sc_hs__nor2_1_0/B 0
C1414 sky130_fd_sc_hs__dfxtp_1_2/a_1168_124# stored_values.4 0
C1415 count.2 sky130_fd_sc_hs__mux2i_1_1/a_225_74# 0
C1416 sky130_fd_sc_hs__nor2_1_1/B sky130_fd_sc_hs__dfxtp_1_5/a_27_74# 0
C1417 sky130_fd_sc_hs__nor2_1_4/Y sky130_fd_sc_hs__mux2i_1_2/a_114_74# 0
C1418 clk sky130_fd_sc_hs__nor2_1_0/Y 0.08879f
C1419 sky130_fd_sc_hs__nor2_1_4/B sky130_fd_sc_hs__mux2i_1_2/a_426_74# 0
C1420 sky130_fd_sc_hs__mux2i_1_6/a_399_368# stored_values.5 0
C1421 count.3 sky130_fd_sc_hs__mux2i_1_3/a_225_74# 0
C1422 sky130_fd_sc_hs__dfxtp_1_3/a_668_503# stored_values.6 0
C1423 sky130_fd_sc_hs__nor2_1_2/Y enable 0.00136f
C1424 stored_values.7 sky130_fd_sc_hs__mux2i_1_3/a_225_74# 0.00217f
C1425 sky130_fd_sc_hs__dfxtp_1_5/a_1011_424# sky130_fd_sc_hs__nor2_1_1/B 0
C1426 sky130_fd_sc_hs__dfxtp_1_4/a_27_74# reset 0.01032f
C1427 sky130_fd_sc_hs__mux2i_1_4/a_399_368# enable 0.0036f
C1428 sky130_fd_sc_hs__mux2i_1_7/a_399_368# sky130_fd_sc_hs__nor2_1_1/a_116_368# 0
C1429 reset sky130_fd_sc_hs__mux2i_1_7/a_399_368# 0.00101f
C1430 sky130_fd_sc_hs__nor2_1_4/Y sky130_fd_sc_hs__dfxtp_1_3/a_561_463# 0.00312f
C1431 VPWR sky130_fd_sc_hs__mux2i_1_1/a_399_368# 0.07173f
C1432 VPWR sky130_fd_sc_hs__nor2_1_1/a_116_368# -0.00101f
C1433 sky130_fd_sc_hs__nor2_1_2/a_116_368# stored_values.4 0.00189f
C1434 VPWR sky130_fd_sc_hs__nor2_1_5/B -0.00554f
C1435 sky130_fd_sc_hs__dfxtp_1_0/a_561_463# enable 0
C1436 count.2 sky130_fd_sc_hs__dfxtp_1_4/a_1210_314# 0
C1437 clk sky130_fd_sc_hs__dfxtp_1_5/a_561_463# 0.00511f
C1438 VPWR reset 3.38266f
C1439 sky130_fd_sc_hs__dfxtp_1_2/a_1011_424# sky130_fd_sc_hs__nor2_1_4/B 0
C1440 sky130_fd_sc_hs__dfxtp_1_7/a_561_463# sky130_fd_sc_hs__dfxtp_1_5/a_713_458# 0
C1441 sky130_fd_sc_hs__dfxtp_1_7/a_713_458# sky130_fd_sc_hs__dfxtp_1_5/a_561_463# 0
C1442 count.6 sky130_fd_sc_hs__nor2_1_5/Y 0.01444f
C1443 sky130_fd_sc_hs__mux2i_1_4/a_225_74# count.0 0.01084f
C1444 clk sky130_fd_sc_hs__dfxtp_1_2/a_731_101# 0
C1445 sky130_fd_sc_hs__dfxtp_1_7/a_731_101# enable 0
C1446 sky130_fd_sc_hs__mux2i_1_2/a_114_74# enable 0.02091f
C1447 sky130_fd_sc_hs__dfxtp_1_4/a_668_503# enable 0
C1448 VPWR sky130_fd_sc_hs__nor2_1_5/a_116_368# -0
C1449 enable stored_values.0 0.22293f
C1450 stored_values.1 sky130_fd_sc_hs__mux2i_1_5/a_399_368# 0
C1451 sky130_fd_sc_hs__dfxtp_1_0/a_206_368# sky130_fd_sc_hs__dfxtp_1_1/a_1011_424# 0
C1452 count.4 sky130_fd_sc_hs__mux2i_1_0/a_399_368# 0.0263f
C1453 sky130_fd_sc_hs__dfxtp_1_3/a_1118_508# reset 0
C1454 sky130_fd_sc_hs__mux2i_1_5/a_114_74# sky130_fd_sc_hs__dfxtp_1_5/a_206_368# 0
C1455 stored_values.3 enable 0.08302f
C1456 sky130_fd_sc_hs__dfxtp_1_6/a_561_463# stored_values.0 0.05205f
C1457 clk sky130_fd_sc_hs__dfxtp_1_5/a_1168_124# 0
C1458 sky130_fd_sc_hs__nor2_1_3/Y sky130_fd_sc_hs__nor2_1_1/B 0.00259f
C1459 sky130_fd_sc_hs__nor2_1_2/Y sky130_fd_sc_hs__dfxtp_1_2/a_206_368# 0.05711f
C1460 reset sky130_fd_sc_hs__dfxtp_1_2/a_1210_314# 0.00621f
C1461 sky130_fd_sc_hs__nor2_1_7/Y sky130_fd_sc_hs__mux2i_1_6/a_223_368# 0.00115f
C1462 stored_values.3 sky130_fd_sc_hs__dfxtp_1_0/a_454_503# 0.01297f
C1463 sky130_fd_sc_hs__dfxtp_1_3/a_1011_424# sky130_fd_sc_hs__mux2i_1_1/a_114_74# 0
C1464 reset sky130_fd_sc_hs__dfxtp_1_1/a_454_503# 0.00214f
C1465 sky130_fd_sc_hs__dfxtp_1_3/a_561_463# enable 0.00119f
C1466 count.4 sky130_fd_sc_hs__mux2i_1_4/a_225_74# 0.00101f
C1467 VPWR sky130_fd_sc_hs__dfxtp_1_4/a_561_463# -0.01677f
C1468 clk sky130_fd_sc_hs__mux2i_1_5/a_399_368# 0
C1469 sky130_fd_sc_hs__nor2_1_0/Y sky130_fd_sc_hs__mux2i_1_6/a_114_74# 0
C1470 sky130_fd_sc_hs__mux2i_1_0/a_114_74# enable 0.02329f
C1471 sky130_fd_sc_hs__dfxtp_1_6/a_27_74# sky130_fd_sc_hs__nor2_1_7/Y 0
C1472 VPWR sky130_fd_sc_hs__dfxtp_1_6/a_731_101# -0
C1473 enable sky130_fd_sc_hs__dfxtp_1_1/a_27_74# 0
C1474 sky130_fd_sc_hs__dfxtp_1_6/a_27_74# sky130_fd_sc_hs__nor2_1_0/a_116_368# 0
C1475 stored_values.4 sky130_fd_sc_hs__mux2i_1_4/a_223_368# 0
C1476 sky130_fd_sc_hs__dfxtp_1_3/a_206_368# stored_values.4 0
C1477 stored_values.6 stored_values.5 0.00375f
C1478 sky130_fd_sc_hs__dfxtp_1_2/a_27_74# sky130_fd_sc_hs__dfxtp_1_6/a_713_458# 0
C1479 sky130_fd_sc_hs__mux2i_1_3/a_399_368# sky130_fd_sc_hs__nor2_1_1/B 0
C1480 sky130_fd_sc_hs__dfxtp_1_0/a_561_463# sky130_fd_sc_hs__dfxtp_1_1/a_713_458# 0
C1481 sky130_fd_sc_hs__dfxtp_1_3/a_1011_424# sky130_fd_sc_hs__dfxtp_1_4/a_1210_314# 0
C1482 sky130_fd_sc_hs__dfxtp_1_3/a_1210_314# sky130_fd_sc_hs__dfxtp_1_4/a_1011_424# 0
C1483 sky130_fd_sc_hs__dfxtp_1_2/a_206_368# sky130_fd_sc_hs__mux2i_1_2/a_114_74# 0
C1484 reset sky130_fd_sc_hs__mux2i_1_2/a_225_74# 0.00722f
C1485 sky130_fd_sc_hs__dfxtp_1_7/a_27_74# count.6 0.00347f
C1486 sky130_fd_sc_hs__dfxtp_1_7/a_206_368# stored_values.6 0.18658f
C1487 sky130_fd_sc_hs__nor2_1_2/Y sky130_fd_sc_hs__nor2_1_2/B 0.0889f
C1488 sky130_fd_sc_hs__nor2_1_4/a_116_368# sky130_fd_sc_hs__nor2_1_4/B 0
C1489 count.4 count.0 0.0047f
C1490 sky130_fd_sc_hs__nor2_1_3/a_116_368# count.7 0
C1491 sky130_fd_sc_hs__nor2_1_3/B sky130_fd_sc_hs__dfxtp_1_7/a_1011_424# 0
C1492 sky130_fd_sc_hs__dfxtp_1_4/a_206_368# sky130_fd_sc_hs__nor2_1_7/Y 0.06541f
C1493 count.7 sky130_fd_sc_hs__dfxtp_1_1/a_27_74# 0.00379f
C1494 sky130_fd_sc_hs__dfxtp_1_6/a_1011_424# sky130_fd_sc_hs__nor2_1_7/Y 0
C1495 reset count.1 0.14082f
C1496 sky130_fd_sc_hs__dfxtp_1_3/a_27_74# stored_values.1 0
C1497 count.3 sky130_fd_sc_hs__nor2_1_1/B 0.05798f
C1498 reset sky130_fd_sc_hs__dfxtp_1_5/a_27_74# 0.00993f
C1499 clk sky130_fd_sc_hs__mux2i_1_1/a_225_74# 0.0018f
C1500 sky130_fd_sc_hs__nor2_1_7/B sky130_fd_sc_hs__mux2i_1_2/a_399_368# 0
C1501 stored_values.7 sky130_fd_sc_hs__nor2_1_1/B 0.00184f
C1502 sky130_fd_sc_hs__dfxtp_1_2/a_668_503# reset 0
C1503 sky130_fd_sc_hs__dfxtp_1_2/a_206_368# sky130_fd_sc_hs__mux2i_1_0/a_114_74# 0
C1504 sky130_fd_sc_hs__mux2i_1_6/a_426_74# enable 0
C1505 sky130_fd_sc_hs__dfxtp_1_0/a_1011_424# sky130_fd_sc_hs__nor2_1_1/Y 0
C1506 sky130_fd_sc_hs__dfxtp_1_2/a_27_74# count.4 0.00334f
C1507 sky130_fd_sc_hs__dfxtp_1_3/a_27_74# count.5 0.00339f
C1508 sky130_fd_sc_hs__dfxtp_1_3/a_206_368# stored_values.5 0.1971f
C1509 sky130_fd_sc_hs__dfxtp_1_2/a_1011_424# sky130_fd_sc_hs__dfxtp_1_6/a_206_368# 0
C1510 sky130_fd_sc_hs__dfxtp_1_7/a_1118_508# count.6 0
C1511 sky130_fd_sc_hs__dfxtp_1_7/a_561_463# sky130_fd_sc_hs__nor2_1_5/B 0
C1512 sky130_fd_sc_hs__dfxtp_1_7/a_1210_314# sky130_fd_sc_hs__mux2i_1_3/a_225_74# 0
C1513 sky130_fd_sc_hs__dfxtp_1_7/a_1011_424# sky130_fd_sc_hs__mux2i_1_3/a_114_74# 0
C1514 sky130_fd_sc_hs__mux2i_1_7/a_225_74# sky130_fd_sc_hs__nor2_1_1/B 0.02901f
C1515 sky130_fd_sc_hs__mux2i_1_7/a_223_368# sky130_fd_sc_hs__nor2_1_1/Y 0
C1516 reset sky130_fd_sc_hs__dfxtp_1_7/a_561_463# 0.00445f
C1517 sky130_fd_sc_hs__nor2_1_2/B stored_values.0 0.00112f
C1518 sky130_fd_sc_hs__mux2i_1_6/a_225_74# sky130_fd_sc_hs__dfxtp_1_6/a_1210_314# 0
C1519 VPWR sky130_fd_sc_hs__nor2_1_0/Y 0.00741f
C1520 clk sky130_fd_sc_hs__dfxtp_1_3/a_27_74# 0.05272f
C1521 sky130_fd_sc_hs__nor2_1_7/B stored_values.1 0.06714f
C1522 clk sky130_fd_sc_hs__mux2i_1_4/a_114_74# 0
C1523 reset sky130_fd_sc_hs__dfxtp_1_5/a_1011_424# 0.00239f
C1524 sky130_fd_sc_hs__nor2_1_3/B stored_values.6 0
C1525 sky130_fd_sc_hs__dfxtp_1_4/a_1210_314# stored_values.1 0.04078f
C1526 count.3 sky130_fd_sc_hs__dfxtp_1_5/a_713_458# 0
C1527 clk sky130_fd_sc_hs__mux2i_1_1/a_114_74# 0
C1528 sky130_fd_sc_hs__nor2_1_7/B count.5 0.00805f
C1529 clk sky130_fd_sc_hs__nor2_1_7/B 0.14745f
C1530 sky130_fd_sc_hs__mux2i_1_0/a_114_74# sky130_fd_sc_hs__nor2_1_2/B 0.00174f
C1531 clk sky130_fd_sc_hs__dfxtp_1_4/a_1210_314# 0.00193f
C1532 stored_values.6 sky130_fd_sc_hs__mux2i_1_3/a_114_74# 0.00146f
C1533 count.2 sky130_fd_sc_hs__mux2i_1_5/a_225_74# 0.0084f
C1534 VPWR sky130_fd_sc_hs__dfxtp_1_5/a_561_463# -0.01624f
C1535 VPWR sky130_fd_sc_hs__dfxtp_1_2/a_731_101# -0
C1536 count.7 sky130_fd_sc_hs__dfxtp_1_1/a_1118_508# 0
C1537 sky130_fd_sc_hs__dfxtp_1_3/a_713_458# stored_values.5 0.02424f
C1538 stored_values.3 sky130_fd_sc_hs__dfxtp_1_5/a_1210_314# 0
C1539 reset sky130_fd_sc_hs__nor2_1_3/Y 0.02673f
C1540 stored_values.3 sky130_fd_sc_hs__dfxtp_1_0/a_206_368# 0.18652f
C1541 sky130_fd_sc_hs__dfxtp_1_4/a_206_368# sky130_fd_sc_hs__mux2i_1_5/a_223_368# 0
C1542 sky130_fd_sc_hs__dfxtp_1_4/a_713_458# sky130_fd_sc_hs__mux2i_1_5/a_114_74# 0
C1543 VPWR sky130_fd_sc_hs__dfxtp_1_7/a_668_503# -0
C1544 count.2 stored_values.6 0
C1545 VPWR sky130_fd_sc_hs__dfxtp_1_5/a_1168_124# -0
C1546 sky130_fd_sc_hs__nor2_1_6/B enable 0.01211f
C1547 VPWR sky130_fd_sc_hs__mux2i_1_5/a_399_368# 0.0721f
C1548 sky130_fd_sc_hs__dfxtp_1_0/a_206_368# sky130_fd_sc_hs__dfxtp_1_1/a_27_74# 0
C1549 sky130_fd_sc_hs__dfxtp_1_0/a_27_74# sky130_fd_sc_hs__dfxtp_1_1/a_206_368# 0
C1550 clk sky130_fd_sc_hs__mux2i_1_0/a_225_74# 0.00185f
C1551 reset sky130_fd_sc_hs__mux2i_1_3/a_399_368# 0.00577f
C1552 sky130_fd_sc_hs__nor2_1_7/Y sky130_fd_sc_hs__nor2_1_4/B 0
C1553 reset sky130_fd_sc_hs__dfxtp_1_6/a_27_74# 0.01044f
C1554 sky130_fd_sc_hs__dfxtp_1_4/a_1168_124# enable 0
C1555 sky130_fd_sc_hs__mux2i_1_6/a_399_368# stored_values.1 0.08f
C1556 sky130_fd_sc_hs__nor2_1_1/B sky130_fd_sc_hs__dfxtp_1_5/a_206_368# 0
C1557 reset sky130_fd_sc_hs__mux2i_1_1/a_223_368# 0.00392f
C1558 sky130_fd_sc_hs__nor2_1_7/B sky130_fd_sc_hs__mux2i_1_6/a_114_74# 0.0027f
C1559 sky130_fd_sc_hs__nor2_1_4/Y sky130_fd_sc_hs__mux2i_1_2/a_223_368# 0.00114f
C1560 count.3 sky130_fd_sc_hs__nor2_1_1/a_116_368# 0
C1561 sky130_fd_sc_hs__mux2i_1_6/a_399_368# count.5 0
C1562 sky130_fd_sc_hs__mux2i_1_6/a_225_74# stored_values.5 0
C1563 sky130_fd_sc_hs__mux2i_1_5/a_114_74# sky130_fd_sc_hs__nor2_1_7/Y 0
C1564 clk sky130_fd_sc_hs__nor2_1_1/Y 0.09713f
C1565 sky130_fd_sc_hs__dfxtp_1_3/a_1011_424# stored_values.6 0.0011f
C1566 count.3 reset 0.14077f
C1567 clk sky130_fd_sc_hs__mux2i_1_6/a_399_368# 0
C1568 sky130_fd_sc_hs__dfxtp_1_4/a_206_368# reset 0.00486f
C1569 reset stored_values.7 0.13934f
C1570 sky130_fd_sc_hs__mux2i_1_4/a_225_74# enable 0.009f
C1571 reset sky130_fd_sc_hs__dfxtp_1_6/a_1011_424# 0.00244f
C1572 sky130_fd_sc_hs__dfxtp_1_4/a_27_74# sky130_fd_sc_hs__dfxtp_1_3/a_27_74# 0.01204f
C1573 VPWR sky130_fd_sc_hs__mux2i_1_1/a_225_74# -0.00113f
C1574 reset sky130_fd_sc_hs__mux2i_1_7/a_225_74# 0.00722f
C1575 sky130_fd_sc_hs__nor2_1_4/Y sky130_fd_sc_hs__dfxtp_1_3/a_1210_314# 0
C1576 sky130_fd_sc_hs__nor2_1_4/Y sky130_fd_sc_hs__dfxtp_1_2/a_27_74# 0
C1577 sky130_fd_sc_hs__nor2_1_2/Y sky130_fd_sc_hs__nor2_1_0/B 0.00255f
C1578 sky130_fd_sc_hs__nor2_1_6/B sky130_fd_sc_hs__nor2_1_5/Y 0.00262f
C1579 sky130_fd_sc_hs__dfxtp_1_6/a_713_458# enable 0.00226f
C1580 stored_values.2 sky130_fd_sc_hs__dfxtp_1_4/a_668_503# 0
C1581 sky130_fd_sc_hs__dfxtp_1_7/a_561_463# sky130_fd_sc_hs__dfxtp_1_5/a_561_463# 0.00381f
C1582 sky130_fd_sc_hs__mux2i_1_4/a_399_368# sky130_fd_sc_hs__nor2_1_0/B 0.00139f
C1583 VPWR sky130_fd_sc_hs__dfxtp_1_3/a_27_74# -0.02597f
C1584 clk sky130_fd_sc_hs__dfxtp_1_2/a_1168_124# 0
C1585 sky130_fd_sc_hs__dfxtp_1_7/a_1168_124# enable 0
C1586 VPWR sky130_fd_sc_hs__mux2i_1_4/a_114_74# 0
C1587 sky130_fd_sc_hs__dfxtp_1_4/a_27_74# sky130_fd_sc_hs__nor2_1_7/B 0.01167f
C1588 sky130_fd_sc_hs__dfxtp_1_4/a_1011_424# enable 0.00802f
C1589 stored_values.2 stored_values.3 0
C1590 sky130_fd_sc_hs__dfxtp_1_2/a_206_368# sky130_fd_sc_hs__mux2i_1_0/a_399_368# 0
C1591 sky130_fd_sc_hs__dfxtp_1_3/a_731_101# sky130_fd_sc_hs__nor2_1_5/B 0
C1592 enable count.0 0.1118f
C1593 VPWR sky130_fd_sc_hs__mux2i_1_1/a_114_74# 0.00816f
C1594 sky130_fd_sc_hs__dfxtp_1_3/a_731_101# reset 0
C1595 clk sky130_fd_sc_hs__dfxtp_1_7/a_1011_424# 0.00132f
C1596 sky130_fd_sc_hs__mux2i_1_5/a_223_368# sky130_fd_sc_hs__dfxtp_1_5/a_206_368# 0
C1597 sky130_fd_sc_hs__dfxtp_1_6/a_1210_314# stored_values.0 0.05686f
C1598 sky130_fd_sc_hs__nor2_1_2/Y sky130_fd_sc_hs__dfxtp_1_2/a_713_458# 0
C1599 stored_values.3 sky130_fd_sc_hs__dfxtp_1_0/a_668_503# 0
C1600 VPWR sky130_fd_sc_hs__nor2_1_7/B -0
C1601 sky130_fd_sc_hs__dfxtp_1_2/a_1210_314# sky130_fd_sc_hs__dfxtp_1_3/a_27_74# 0
C1602 sky130_fd_sc_hs__dfxtp_1_3/a_1210_314# enable 0.02459f
C1603 stored_values.0 sky130_fd_sc_hs__nor2_1_0/B 0.06437f
C1604 VPWR sky130_fd_sc_hs__dfxtp_1_4/a_1210_314# -0.01028f
C1605 clk sky130_fd_sc_hs__mux2i_1_5/a_225_74# 0.00243f
C1606 sky130_fd_sc_hs__nor2_1_0/Y sky130_fd_sc_hs__mux2i_1_6/a_223_368# 0
C1607 sky130_fd_sc_hs__dfxtp_1_2/a_27_74# enable 0.00293f
C1608 sky130_fd_sc_hs__dfxtp_1_6/a_206_368# sky130_fd_sc_hs__nor2_1_7/Y 0
C1609 sky130_fd_sc_hs__dfxtp_1_4/a_1118_508# enable 0
C1610 sky130_fd_sc_hs__mux2i_1_7/a_114_74# stored_values.3 0.01913f
C1611 count.4 enable 0.00351f
C1612 sky130_fd_sc_hs__nor2_1_2/Y stored_values.4 0.29239f
C1613 enable sky130_fd_sc_hs__dfxtp_1_1/a_206_368# 0
C1614 count.6 stored_values.5 0
C1615 sky130_fd_sc_hs__dfxtp_1_2/a_27_74# sky130_fd_sc_hs__dfxtp_1_6/a_561_463# 0
C1616 stored_values.4 sky130_fd_sc_hs__mux2i_1_4/a_399_368# 0
C1617 sky130_fd_sc_hs__nor2_1_7/a_116_368# enable 0
C1618 sky130_fd_sc_hs__mux2i_1_3/a_225_74# sky130_fd_sc_hs__nor2_1_1/B 0.00198f
C1619 sky130_fd_sc_hs__dfxtp_1_0/a_561_463# sky130_fd_sc_hs__dfxtp_1_1/a_561_463# 0.00396f
C1620 sky130_fd_sc_hs__nor2_1_2/B sky130_fd_sc_hs__mux2i_1_0/a_399_368# 0
C1621 sky130_fd_sc_hs__nor2_1_0/Y sky130_fd_sc_hs__dfxtp_1_6/a_27_74# 0.1322f
C1622 sky130_fd_sc_hs__nor2_1_3/B sky130_fd_sc_hs__dfxtp_1_1/a_1011_424# 0
C1623 clk stored_values.6 0.00488f
C1624 sky130_fd_sc_hs__nor2_1_6/B sky130_fd_sc_hs__dfxtp_1_5/a_1210_314# 0
C1625 sky130_fd_sc_hs__dfxtp_1_2/a_713_458# sky130_fd_sc_hs__mux2i_1_2/a_114_74# 0
C1626 sky130_fd_sc_hs__dfxtp_1_2/a_206_368# sky130_fd_sc_hs__mux2i_1_2/a_223_368# 0
C1627 sky130_fd_sc_hs__dfxtp_1_7/a_206_368# count.6 0.00286f
C1628 sky130_fd_sc_hs__dfxtp_1_7/a_713_458# stored_values.6 0.01952f
C1629 reset sky130_fd_sc_hs__mux2i_1_2/a_426_74# 0
C1630 sky130_fd_sc_hs__dfxtp_1_3/a_206_368# sky130_fd_sc_hs__mux2i_1_2/a_399_368# 0
C1631 sky130_fd_sc_hs__mux2i_1_5/a_426_74# sky130_fd_sc_hs__nor2_1_6/B 0.00121f
C1632 sky130_fd_sc_hs__dfxtp_1_4/a_713_458# sky130_fd_sc_hs__nor2_1_7/Y 0
C1633 count.7 sky130_fd_sc_hs__dfxtp_1_1/a_206_368# 0.00312f
C1634 VPWR sky130_fd_sc_hs__mux2i_1_0/a_225_74# -0.00113f
C1635 stored_values.4 sky130_fd_sc_hs__mux2i_1_2/a_114_74# 0.00142f
C1636 stored_values.4 stored_values.0 0.01137f
C1637 reset sky130_fd_sc_hs__dfxtp_1_5/a_206_368# 0.00493f
C1638 VPWR VGND -9.3553f
C1639 sky130_fd_sc_hs__dfxtp_1_7/a_1118_508# VGND -0
C1640 sky130_fd_sc_hs__dfxtp_1_7/a_1011_424# VGND 0
C1641 sky130_fd_sc_hs__dfxtp_1_7/a_668_503# VGND -0
C1642 sky130_fd_sc_hs__dfxtp_1_7/a_454_503# VGND -0
C1643 sky130_fd_sc_hs__dfxtp_1_7/a_1210_314# VGND 0.00334f
C1644 sky130_fd_sc_hs__dfxtp_1_7/a_561_463# VGND 0
C1645 sky130_fd_sc_hs__dfxtp_1_7/a_713_458# VGND 0
C1646 sky130_fd_sc_hs__dfxtp_1_7/a_206_368# VGND 0.00578f
C1647 sky130_fd_sc_hs__dfxtp_1_7/a_27_74# VGND 0.05357f
C1648 sky130_fd_sc_hs__nor2_1_7/Y VGND -0.00378f
C1649 sky130_fd_sc_hs__nor2_1_7/a_116_368# VGND -0
C1650 sky130_fd_sc_hs__dfxtp_1_6/a_1118_508# VGND -0
C1651 sky130_fd_sc_hs__dfxtp_1_6/a_1011_424# VGND 0
C1652 sky130_fd_sc_hs__dfxtp_1_6/a_668_503# VGND -0
C1653 sky130_fd_sc_hs__dfxtp_1_6/a_454_503# VGND -0
C1654 sky130_fd_sc_hs__dfxtp_1_6/a_1210_314# VGND 0.0032f
C1655 sky130_fd_sc_hs__dfxtp_1_6/a_561_463# VGND 0
C1656 sky130_fd_sc_hs__dfxtp_1_6/a_713_458# VGND 0
C1657 sky130_fd_sc_hs__dfxtp_1_6/a_206_368# VGND 0.00582f
C1658 sky130_fd_sc_hs__dfxtp_1_6/a_27_74# VGND 0.05374f
C1659 sky130_fd_sc_hs__nor2_1_6/Y VGND -0.00687f
C1660 sky130_fd_sc_hs__nor2_1_6/B VGND 0.15573f
C1661 sky130_fd_sc_hs__nor2_1_6/a_116_368# VGND -0
C1662 sky130_fd_sc_hs__dfxtp_1_5/a_1118_508# VGND -0
C1663 sky130_fd_sc_hs__dfxtp_1_5/a_1011_424# VGND 0
C1664 sky130_fd_sc_hs__dfxtp_1_5/a_668_503# VGND -0
C1665 sky130_fd_sc_hs__dfxtp_1_5/a_454_503# VGND -0
C1666 sky130_fd_sc_hs__dfxtp_1_5/a_1210_314# VGND 0.0033f
C1667 sky130_fd_sc_hs__dfxtp_1_5/a_561_463# VGND 0
C1668 sky130_fd_sc_hs__dfxtp_1_5/a_713_458# VGND 0
C1669 sky130_fd_sc_hs__dfxtp_1_5/a_206_368# VGND 0.00602f
C1670 sky130_fd_sc_hs__dfxtp_1_5/a_27_74# VGND 0.05384f
C1671 sky130_fd_sc_hs__nor2_1_5/Y VGND -0.00908f
C1672 sky130_fd_sc_hs__nor2_1_5/a_116_368# VGND -0
C1673 sky130_fd_sc_hs__dfxtp_1_4/a_1118_508# VGND -0
C1674 sky130_fd_sc_hs__dfxtp_1_4/a_1011_424# VGND 0
C1675 sky130_fd_sc_hs__dfxtp_1_4/a_668_503# VGND -0
C1676 sky130_fd_sc_hs__dfxtp_1_4/a_454_503# VGND -0
C1677 sky130_fd_sc_hs__dfxtp_1_4/a_1210_314# VGND 0.00346f
C1678 sky130_fd_sc_hs__dfxtp_1_4/a_561_463# VGND 0
C1679 sky130_fd_sc_hs__dfxtp_1_4/a_713_458# VGND 0
C1680 sky130_fd_sc_hs__dfxtp_1_4/a_206_368# VGND 0.00617f
C1681 sky130_fd_sc_hs__dfxtp_1_4/a_27_74# VGND 0.05372f
C1682 sky130_fd_sc_hs__nor2_1_4/Y VGND -0.00882f
C1683 sky130_fd_sc_hs__nor2_1_4/a_116_368# VGND -0
C1684 sky130_fd_sc_hs__dfxtp_1_3/a_1118_508# VGND -0
C1685 sky130_fd_sc_hs__dfxtp_1_3/a_1011_424# VGND 0
C1686 sky130_fd_sc_hs__dfxtp_1_3/a_668_503# VGND -0
C1687 sky130_fd_sc_hs__dfxtp_1_3/a_454_503# VGND -0
C1688 sky130_fd_sc_hs__dfxtp_1_3/a_1210_314# VGND 0.00308f
C1689 sky130_fd_sc_hs__dfxtp_1_3/a_561_463# VGND 0
C1690 sky130_fd_sc_hs__dfxtp_1_3/a_713_458# VGND 0
C1691 sky130_fd_sc_hs__dfxtp_1_3/a_206_368# VGND 0.00556f
C1692 sky130_fd_sc_hs__dfxtp_1_3/a_27_74# VGND 0.05347f
C1693 sky130_fd_sc_hs__nor2_1_3/Y VGND -0.01234f
C1694 sky130_fd_sc_hs__nor2_1_3/B VGND 0.17745f
C1695 sky130_fd_sc_hs__nor2_1_3/a_116_368# VGND -0
C1696 count.3 VGND 0.05237f
C1697 stored_values.3 VGND 0.23234f
C1698 sky130_fd_sc_hs__mux2i_1_7/a_225_74# VGND 0.0394f
C1699 sky130_fd_sc_hs__mux2i_1_7/a_399_368# VGND -0.00182f
C1700 sky130_fd_sc_hs__mux2i_1_7/a_223_368# VGND -0.00145f
C1701 sky130_fd_sc_hs__mux2i_1_7/a_114_74# VGND 0.00828f
C1702 sky130_fd_sc_hs__nor2_1_2/Y VGND -0.0075f
C1703 reset VGND 4.10734f
C1704 sky130_fd_sc_hs__nor2_1_2/a_116_368# VGND -0
C1705 clk VGND 4.66832f
C1706 sky130_fd_sc_hs__dfxtp_1_2/a_1118_508# VGND -0
C1707 sky130_fd_sc_hs__dfxtp_1_2/a_1011_424# VGND 0
C1708 sky130_fd_sc_hs__dfxtp_1_2/a_668_503# VGND -0
C1709 sky130_fd_sc_hs__dfxtp_1_2/a_454_503# VGND -0
C1710 sky130_fd_sc_hs__dfxtp_1_2/a_1210_314# VGND 0.00313f
C1711 sky130_fd_sc_hs__dfxtp_1_2/a_561_463# VGND 0
C1712 sky130_fd_sc_hs__dfxtp_1_2/a_713_458# VGND 0
C1713 sky130_fd_sc_hs__dfxtp_1_2/a_206_368# VGND 0.00562f
C1714 sky130_fd_sc_hs__dfxtp_1_2/a_27_74# VGND 0.05356f
C1715 sky130_fd_sc_hs__nor2_1_7/B VGND 0.15334f
C1716 count.1 VGND 0.03777f
C1717 stored_values.1 VGND 0.19879f
C1718 sky130_fd_sc_hs__mux2i_1_6/a_225_74# VGND 0.0394f
C1719 sky130_fd_sc_hs__mux2i_1_6/a_399_368# VGND -0.00182f
C1720 sky130_fd_sc_hs__mux2i_1_6/a_223_368# VGND -0.00145f
C1721 sky130_fd_sc_hs__mux2i_1_6/a_114_74# VGND 0.0084f
C1722 sky130_fd_sc_hs__dfxtp_1_1/a_1118_508# VGND -0
C1723 sky130_fd_sc_hs__dfxtp_1_1/a_1011_424# VGND 0
C1724 sky130_fd_sc_hs__dfxtp_1_1/a_668_503# VGND -0
C1725 sky130_fd_sc_hs__dfxtp_1_1/a_454_503# VGND -0
C1726 sky130_fd_sc_hs__dfxtp_1_1/a_1210_314# VGND 0
C1727 sky130_fd_sc_hs__dfxtp_1_1/a_561_463# VGND 0
C1728 sky130_fd_sc_hs__dfxtp_1_1/a_713_458# VGND 0
C1729 sky130_fd_sc_hs__dfxtp_1_1/a_206_368# VGND 0.00573f
C1730 sky130_fd_sc_hs__dfxtp_1_1/a_27_74# VGND 0.05337f
C1731 sky130_fd_sc_hs__nor2_1_0/B VGND 0.14945f
C1732 count.0 VGND 0.05976f
C1733 stored_values.0 VGND 0.26615f
C1734 sky130_fd_sc_hs__mux2i_1_4/a_225_74# VGND 0.0394f
C1735 sky130_fd_sc_hs__mux2i_1_4/a_399_368# VGND -0.00179f
C1736 sky130_fd_sc_hs__mux2i_1_4/a_223_368# VGND -0.00146f
C1737 sky130_fd_sc_hs__mux2i_1_4/a_114_74# VGND 0
C1738 count.2 VGND 0.03368f
C1739 stored_values.2 VGND 0.2396f
C1740 sky130_fd_sc_hs__mux2i_1_5/a_225_74# VGND 0.0394f
C1741 sky130_fd_sc_hs__mux2i_1_5/a_399_368# VGND -0.00181f
C1742 sky130_fd_sc_hs__mux2i_1_5/a_223_368# VGND -0.00147f
C1743 sky130_fd_sc_hs__mux2i_1_5/a_114_74# VGND 0.00826f
C1744 sky130_fd_sc_hs__dfxtp_1_0/a_1168_124# VGND 0
C1745 sky130_fd_sc_hs__dfxtp_1_0/a_731_101# VGND 0
C1746 sky130_fd_sc_hs__dfxtp_1_0/a_1118_508# VGND -0
C1747 sky130_fd_sc_hs__dfxtp_1_0/a_1011_424# VGND 0.00243f
C1748 sky130_fd_sc_hs__dfxtp_1_0/a_668_503# VGND -0
C1749 sky130_fd_sc_hs__dfxtp_1_0/a_454_503# VGND 0
C1750 sky130_fd_sc_hs__dfxtp_1_0/a_1210_314# VGND 0.00433f
C1751 sky130_fd_sc_hs__dfxtp_1_0/a_561_463# VGND 0
C1752 sky130_fd_sc_hs__dfxtp_1_0/a_713_458# VGND 0.00148f
C1753 sky130_fd_sc_hs__dfxtp_1_0/a_206_368# VGND 0.00691f
C1754 sky130_fd_sc_hs__dfxtp_1_0/a_27_74# VGND 0.0548f
C1755 sky130_fd_sc_hs__nor2_1_1/Y VGND -0.006f
C1756 sky130_fd_sc_hs__nor2_1_1/B VGND 0.1625f
C1757 sky130_fd_sc_hs__nor2_1_1/a_116_368# VGND -0
C1758 sky130_fd_sc_hs__nor2_1_0/Y VGND -0.00407f
C1759 sky130_fd_sc_hs__nor2_1_0/a_116_368# VGND -0
C1760 count.7 VGND 0.11384f
C1761 stored_values.7 VGND 0.26277f
C1762 sky130_fd_sc_hs__mux2i_1_3/a_225_74# VGND 0.03676f
C1763 sky130_fd_sc_hs__mux2i_1_3/a_399_368# VGND -0.0018f
C1764 sky130_fd_sc_hs__mux2i_1_3/a_223_368# VGND -0.00143f
C1765 sky130_fd_sc_hs__mux2i_1_3/a_114_74# VGND 0.00839f
C1766 sky130_fd_sc_hs__nor2_1_4/B VGND 0.17876f
C1767 count.5 VGND 0.10615f
C1768 stored_values.5 VGND 0.26099f
C1769 sky130_fd_sc_hs__mux2i_1_2/a_225_74# VGND 0.03676f
C1770 sky130_fd_sc_hs__mux2i_1_2/a_399_368# VGND -0.00181f
C1771 sky130_fd_sc_hs__mux2i_1_2/a_223_368# VGND -0.00143f
C1772 sky130_fd_sc_hs__mux2i_1_2/a_114_74# VGND 0.00841f
C1773 sky130_fd_sc_hs__nor2_1_5/B VGND 0.18837f
C1774 count.6 VGND 0.10501f
C1775 stored_values.6 VGND 0.24158f
C1776 sky130_fd_sc_hs__mux2i_1_1/a_225_74# VGND 0.03665f
C1777 sky130_fd_sc_hs__mux2i_1_1/a_399_368# VGND -0.00181f
C1778 sky130_fd_sc_hs__mux2i_1_1/a_223_368# VGND -0.00145f
C1779 sky130_fd_sc_hs__mux2i_1_1/a_114_74# VGND 0.00833f
C1780 sky130_fd_sc_hs__nor2_1_2/B VGND 0.18704f
C1781 count.4 VGND 0.08723f
C1782 stored_values.4 VGND 0.2425f
C1783 enable VGND 3.02487f
C1784 sky130_fd_sc_hs__mux2i_1_0/a_225_74# VGND 0.03697f
C1785 sky130_fd_sc_hs__mux2i_1_0/a_399_368# VGND -0.00182f
C1786 sky130_fd_sc_hs__mux2i_1_0/a_223_368# VGND -0.00146f
C1787 sky130_fd_sc_hs__mux2i_1_0/a_114_74# VGND 0
.ends
