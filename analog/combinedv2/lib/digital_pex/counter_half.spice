* NGSPICE file created from counter_half_pex.ext - technology: sky130A

.subckt counter_half_pex VPWR rst clk en overflow sky130_fd_sc_hs__and2_1_0.VGND
X0 VGND.t319 sky130_fd_sc_hs__xor2_1_2.X.t3 a_5647_n397.t1 VGND.t318 sky130_fd_pr__nfet_01v8_lvt ad=0.15358 pd=1.2 as=0.2805 ps=2.12 w=0.55 l=0.15
X1 a_2341_n1177.t1 en.t0 a_2254_n1177.t2 VGND.t243 sky130_fd_pr__nfet_01v8_lvt ad=0.1376 pd=1.14 as=0.1824 ps=1.85 w=0.64 l=0.15
X2 VPWR.t117 sky130_fd_sc_hs__xor2_1_1.X.t4 a_3535_n397.t0 VPWR.t116 sky130_fd_pr__pfet_01v8 ad=0.2345 pd=1.58 as=0.2478 ps=2.27 w=0.84 l=0.15
X3 a_2437_n46.t0 a_2082_n141.t5 a_2330_n6.t1 VPWR.t42 sky130_fd_pr__pfet_01v8 ad=0.09835 pd=1.005 as=0.09835 ps=1.005 w=0.42 l=0.15
X4 sky130_fd_sc_hs__dfxtp_1_2.D.t1 a_5647_n397.t3 a_5898_n141.t0 VPWR.t184 sky130_fd_pr__pfet_01v8 ad=0.42 pd=2.99 as=0.1512 ps=1.39 w=1.12 l=0.15
X5 sky130_fd_sc_hs__and2_1_5.X.t1 a_8484_n1177.t4 VPWR.t94 VPWR.t93 sky130_fd_pr__pfet_01v8 ad=0.3304 pd=2.83 as=0.1988 ps=1.505 w=1.12 l=0.15
X6 VGND.t211 sky130_fd_sc_hs__xor2_1_3.X.t3 a_7759_n397.t1 VGND.t210 sky130_fd_pr__nfet_01v8_lvt ad=0.15358 pd=1.2 as=0.2805 ps=2.12 w=0.55 l=0.15
X7 a_7818_n921.t0 sky130_fd_sc_hs__and2_1_4.X.t7 VPWR.t109 VPWR.t108 sky130_fd_pr__pfet_01v8 ad=0.135 pd=1.27 as=0.295 ps=2.59 w=1 l=0.15
X8 VPWR.t317 sky130_fd_sc_hs__and2_1_0.X.t6 a_3033_n945.t2 VPWR.t316 sky130_fd_pr__pfet_01v8 ad=0.2352 pd=1.54 as=0.3752 ps=2.91 w=1.12 l=0.15
X9 a_1626_n1188.t1 sky130_fd_sc_hs__and2_1_0.B.t7 a_1590_n921.t0 VPWR.t159 sky130_fd_pr__pfet_01v8 ad=0.295 pd=2.59 as=0.135 ps=1.27 w=1 l=0.15
X10 VGND.t99 a_5198_n195.t3 a_5156_n385.t0 VGND.t98 sky130_fd_pr__nfet_01v8_lvt ad=0.1197 pd=1.41 as=0.05565 ps=0.685 w=0.42 l=0.15
X11 a_12565_n855.t1 a_12413_n850.t5 VPWR.t212 VPWR.t211 sky130_fd_pr__pfet_01v8 ad=0.2331 pd=1.395 as=0.18985 ps=1.545 w=0.84 l=0.15
X12 VGND.t65 a_1626_n1188.t3 sky130_fd_sc_hs__xor2_1_0.X.t1 VGND.t64 sky130_fd_pr__nfet_01v8_lvt ad=0.2997 pd=2.29 as=0.1554 ps=1.16 w=0.74 l=0.15
X13 a_9261_n945.t1 sky130_fd_sc_hs__and2_1_6.B.t6 VPWR.t127 VPWR.t126 sky130_fd_pr__pfet_01v8 ad=0.196 pd=1.47 as=0.2352 ps=1.54 w=1.12 l=0.15
X14 VPWR.t149 a_8925_n51.t5 a_8880_n6.t0 VPWR.t148 sky130_fd_pr__pfet_01v8 ad=0.18985 pd=1.545 as=0.0504 ps=0.66 w=0.42 l=0.15
X15 VPWR.t236 clk.t7 a_12463_n435.t0 VPWR.t235 sky130_fd_pr__pfet_01v8 ad=0.168 pd=1.42 as=0.3304 ps=2.83 w=1.12 l=0.15
X16 a_11037_n51.t2 a_10885_n46.t5 VPWR.t302 VPWR.t301 sky130_fd_pr__pfet_01v8 ad=0.2331 pd=1.395 as=0.18985 ps=1.545 w=0.84 l=0.15
X17 VGND.t108 a_7111_n85.t4 a_7310_n195.t1 VGND.t107 sky130_fd_pr__nfet_01v8_lvt ad=0.1229 pd=1.085 as=0.1824 ps=1.85 w=0.64 l=0.15
X18 a_4746_n1177.t2 sky130_fd_sc_hs__and2_1_1.X.t5 VPWR.t315 VPWR.t314 sky130_fd_pr__pfet_01v8 ad=0.147 pd=1.19 as=0.252 ps=2.28 w=0.84 l=0.15
X19 a_12583_n1212.t0 a_12058_n945.t3 a_12413_n850.t2 VGND.t39 sky130_fd_pr__nfet_01v8_lvt ad=0.0441 pd=0.63 as=0.07875 ps=0.865 w=0.42 l=0.15
X20 a_9064_n921.t1 sky130_fd_sc_hs__and2_1_5.X.t7 VPWR.t192 VPWR.t191 sky130_fd_pr__pfet_01v8 ad=0.135 pd=1.27 as=0.295 ps=2.59 w=1 l=0.15
X21 VGND.t304 a_7310_n195.t3 a_7268_n385.t1 VGND.t303 sky130_fd_pr__nfet_01v8_lvt ad=0.1197 pd=1.41 as=0.05565 ps=0.685 w=0.42 l=0.15
X22 a_13762_n945.t0 rst.t1 VPWR.t260 VPWR.t259 sky130_fd_pr__pfet_01v8 ad=0.1512 pd=1.39 as=0.2345 ps=1.58 w=1.12 l=0.15
X23 VGND.t254 clk.t10 a_8239_n435.t1 VGND.t253 sky130_fd_pr__nfet_01v8_lvt ad=0.1739 pd=1.21 as=0.2109 ps=2.05 w=0.74 l=0.15
X24 sky130_fd_sc_hs__and2_1_2.B.t0 a_7310_n195.t2 VGND.t78 VGND.t77 sky130_fd_pr__nfet_01v8_lvt ad=0.2109 pd=2.05 as=0.1229 ps=1.085 w=0.74 l=0.15
X25 a_8666_n6.t1 sky130_fd_sc_hs__nor2b_1_3.Y.t4 VPWR.t146 VPWR.t145 sky130_fd_pr__pfet_01v8 ad=0.09835 pd=1.005 as=0.2972 ps=2.41 w=0.42 l=0.15
X26 VGND.t258 clk.t2 a_11879_n1239.t1 VGND.t257 sky130_fd_pr__nfet_01v8_lvt ad=0.1739 pd=1.21 as=0.2109 ps=2.05 w=0.74 l=0.15
X27 a_4116_n1188.t2 sky130_fd_sc_hs__and2_1_1.X.t4 VGND.t295 VGND.t294 sky130_fd_pr__nfet_01v8_lvt ad=0.17738 pd=1.195 as=0.33275 ps=2.31 w=0.55 l=0.15
X28 VPWR.t240 clk.t17 a_1903_n435.t0 VPWR.t239 sky130_fd_pr__pfet_01v8 ad=0.168 pd=1.42 as=0.3304 ps=2.83 w=1.12 l=0.15
X29 VGND.t173 a_9223_n85.t4 a_9422_n195.t1 VGND.t172 sky130_fd_pr__nfet_01v8_lvt ad=0.1229 pd=1.085 as=0.1824 ps=1.85 w=0.64 l=0.15
X30 VGND.t89 sky130_fd_sc_hs__xor2_1_5.B.t4 a_7854_n1188.t1 VGND.t88 sky130_fd_pr__nfet_01v8_lvt ad=0.12607 pd=1.1 as=0.17738 ps=1.195 w=0.55 l=0.15
X31 a_14695_n1212.t0 a_14170_n945.t3 a_14525_n850.t3 VGND.t301 sky130_fd_pr__nfet_01v8_lvt ad=0.0441 pd=0.63 as=0.07875 ps=0.865 w=0.42 l=0.15
X32 a_10501_n945.t0 sky130_fd_sc_hs__and2_1_7.B.t6 VPWR.t54 VPWR.t53 sky130_fd_pr__pfet_01v8 ad=0.196 pd=1.47 as=0.2352 ps=1.54 w=1.12 l=0.15
X33 a_4656_n6.t0 a_4015_n435.t6 a_4549_n46.t1 VPWR.t14 sky130_fd_pr__pfet_01v8 ad=0.0504 pd=0.66 as=0.09835 ps=1.005 w=0.42 l=0.15
X34 sky130_fd_sc_hs__and2_1_3.B.t0 a_9422_n195.t2 VGND.t33 VGND.t32 sky130_fd_pr__nfet_01v8_lvt ad=0.2109 pd=2.05 as=0.1229 ps=1.085 w=0.74 l=0.15
X35 sky130_fd_sc_hs__xor2_1_5.B.t0 a_13646_n195.t4 VPWR.t56 VPWR.t55 sky130_fd_pr__pfet_01v8 ad=0.3304 pd=2.83 as=0.1862 ps=1.475 w=1.12 l=0.15
X36 VGND.t177 a_11399_n1201.t2 sky130_fd_sc_hs__nor2b_1_7.Y.t0 VGND.t176 sky130_fd_pr__nfet_01v8_lvt ad=0.2627 pd=2.19 as=0.13135 ps=1.095 w=0.74 l=0.15
X37 sky130_fd_sc_hs__xor2_1_3.X.t0 sky130_fd_sc_hs__and2_1_3.B.t3 a_5623_n1226.t1 VGND.t307 sky130_fd_pr__nfet_01v8_lvt ad=0.1554 pd=1.16 as=0.0888 ps=0.98 w=0.74 l=0.15
X38 a_9223_n85.t2 a_8418_n141.t2 a_8925_n51.t3 VGND.t201 sky130_fd_pr__nfet_01v8_lvt ad=0.1181 pd=1.035 as=0.10905 ps=1.025 w=0.55 l=0.15
X39 VGND.t35 a_6813_n51.t4 a_6831_n408.t0 VGND.t34 sky130_fd_pr__nfet_01v8_lvt ad=0.1648 pd=1.245 as=0.0441 ps=0.63 w=0.42 l=0.15
X40 a_12863_n889.t2 a_11879_n1239.t4 a_12565_n855.t3 VPWR.t180 sky130_fd_pr__pfet_01v8 ad=0.1428 pd=1.225 as=0.2331 ps=1.395 w=0.84 l=0.15
X41 a_10304_n921.t0 sky130_fd_sc_hs__and2_1_6.X.t7 VPWR.t13 VPWR.t12 sky130_fd_pr__pfet_01v8 ad=0.135 pd=1.27 as=0.295 ps=2.59 w=1 l=0.15
X42 VGND.t111 a_12565_n855.t4 a_12583_n1212.t1 VGND.t110 sky130_fd_pr__nfet_01v8_lvt ad=0.1648 pd=1.245 as=0.0441 ps=0.63 w=0.42 l=0.15
X43 a_5623_n1226.t0 sky130_fd_sc_hs__and2_1_2.X.t3 VGND.t298 VGND.t297 sky130_fd_pr__nfet_01v8_lvt ad=0.0888 pd=0.98 as=0.12607 ps=1.1 w=0.74 l=0.15
X44 a_6554_n6.t1 sky130_fd_sc_hs__dfxtp_1_2.D.t3 VGND.t157 VGND.t156 sky130_fd_pr__nfet_01v8_lvt ad=0.15563 pd=1.215 as=0.23015 ps=2.1 w=0.42 l=0.15
X45 VPWR.t334 a_12863_n889.t5 a_13062_n999.t0 VPWR.t333 sky130_fd_pr__pfet_01v8 ad=0.1862 pd=1.475 as=0.2478 ps=2.27 w=0.84 l=0.15
X46 sky130_fd_sc_hs__xor2_1_5.X.t0 a_7854_n1188.t4 a_8015_n945.t2 VPWR.t327 sky130_fd_pr__pfet_01v8 ad=0.3864 pd=2.93 as=0.196 ps=1.47 w=1.12 l=0.15
X47 a_3502_n1177.t0 sky130_fd_sc_hs__and2_1_0.X.t5 VPWR.t2 VPWR.t1 sky130_fd_pr__pfet_01v8 ad=0.147 pd=1.19 as=0.252 ps=2.28 w=0.84 l=0.15
X48 a_12642_n141.t0 a_12463_n435.t7 VPWR.t52 VPWR.t51 sky130_fd_pr__pfet_01v8 ad=0.3304 pd=2.83 as=0.168 ps=1.42 w=1.12 l=0.15
X49 a_2589_n51.t2 a_2437_n46.t5 VPWR.t161 VPWR.t160 sky130_fd_pr__pfet_01v8 ad=0.2331 pd=1.395 as=0.18985 ps=1.545 w=0.84 l=0.15
X50 sky130_fd_sc_hs__nor2b_1_3.Y.t0 a_7759_n397.t3 a_8010_n141.t0 VPWR.t87 sky130_fd_pr__pfet_01v8 ad=0.42 pd=2.99 as=0.1512 ps=1.39 w=1.12 l=0.15
X51 VGND.t43 a_13511_n1201.t2 sky130_fd_sc_hs__dfxtp_1_0.D.t0 VGND.t42 sky130_fd_pr__nfet_01v8_lvt ad=0.2627 pd=2.19 as=0.13135 ps=1.095 w=0.74 l=0.15
X52 VGND.t336 a_14677_n855.t4 a_14695_n1212.t1 VGND.t335 sky130_fd_pr__nfet_01v8_lvt ad=0.1648 pd=1.245 as=0.0441 ps=0.63 w=0.42 l=0.15
X53 sky130_fd_sc_hs__xor2_1_3.X.t2 a_5362_n1188.t4 a_5523_n945.t0 VPWR.t73 sky130_fd_pr__pfet_01v8 ad=0.3864 pd=2.93 as=0.196 ps=1.47 w=1.12 l=0.15
X54 a_8880_n6.t1 a_8239_n435.t6 a_8773_n46.t1 VPWR.t204 sky130_fd_pr__pfet_01v8 ad=0.0504 pd=0.66 as=0.09835 ps=1.005 w=0.42 l=0.15
X55 sky130_fd_sc_hs__xor2_1_5.X.t2 sky130_fd_sc_hs__xor2_1_5.B.t3 a_8115_n1226.t0 VGND.t13 sky130_fd_pr__nfet_01v8_lvt ad=0.1554 pd=1.16 as=0.0888 ps=0.98 w=0.74 l=0.15
X56 a_8115_n1226.t1 sky130_fd_sc_hs__and2_1_4.X.t3 VGND.t67 VGND.t66 sky130_fd_pr__nfet_01v8_lvt ad=0.0888 pd=0.98 as=0.12607 ps=1.1 w=0.74 l=0.15
X57 sky130_fd_sc_hs__and2_1_3.X.t0 a_5990_n1177.t4 VPWR.t92 VPWR.t91 sky130_fd_pr__pfet_01v8 ad=0.3304 pd=2.83 as=0.1988 ps=1.505 w=1.12 l=0.15
X58 a_2836_n921.t1 sky130_fd_sc_hs__and2_1_0.X.t7 VPWR.t153 VPWR.t152 sky130_fd_pr__pfet_01v8 ad=0.135 pd=1.27 as=0.295 ps=2.59 w=1 l=0.15
X59 a_13167_n408.t0 a_12642_n141.t3 a_12997_n46.t0 VGND.t87 sky130_fd_pr__nfet_01v8_lvt ad=0.0441 pd=0.63 as=0.07875 ps=0.865 w=0.42 l=0.15
X60 a_14525_n850.t0 a_14170_n945.t5 a_14418_n810.t0 VPWR.t74 sky130_fd_pr__pfet_01v8 ad=0.09835 pd=1.005 as=0.09835 ps=1.005 w=0.42 l=0.15
X61 a_14418_n810.t2 sky130_fd_sc_hs__dfxtp_1_0.D.t4 VPWR.t296 VPWR.t295 sky130_fd_pr__pfet_01v8 ad=0.09835 pd=1.005 as=0.2972 ps=2.41 w=0.42 l=0.15
X62 a_4833_n1177.t0 sky130_fd_sc_hs__and2_1_1.X.t2 a_4746_n1177.t0 VGND.t2 sky130_fd_pr__nfet_01v8_lvt ad=0.1376 pd=1.14 as=0.1824 ps=1.85 w=0.64 l=0.15
X63 a_10950_n1177.t1 sky130_fd_sc_hs__and2_1_6.X.t5 VPWR.t30 VPWR.t29 sky130_fd_pr__pfet_01v8 ad=0.147 pd=1.19 as=0.252 ps=2.28 w=0.84 l=0.15
X64 VGND.t155 sky130_fd_sc_hs__and2_1_2.B.t4 a_4116_n1188.t1 VGND.t154 sky130_fd_pr__nfet_01v8_lvt ad=0.12607 pd=1.1 as=0.17738 ps=1.195 w=0.55 l=0.15
X65 a_13020_n1189.t1 a_11879_n1239.t2 a_12863_n889.t3 VGND.t300 sky130_fd_pr__nfet_01v8_lvt ad=0.05565 pd=0.685 as=0.1181 ps=1.035 w=0.42 l=0.15
X66 a_6661_n46.t2 a_6127_n435.t3 a_6554_n6.t3 VGND.t248 sky130_fd_pr__nfet_01v8_lvt ad=0.07875 pd=0.865 as=0.15563 ps=1.215 w=0.42 l=0.15
X67 a_5106_n1.t0 a_4194_n141.t4 a_4999_n85.t1 VPWR.t162 sky130_fd_pr__pfet_01v8 ad=0.09975 pd=0.895 as=0.1428 ps=1.225 w=0.42 l=0.15
X68 a_2607_n408.t1 a_2082_n141.t3 a_2437_n46.t1 VGND.t59 sky130_fd_pr__nfet_01v8_lvt ad=0.0441 pd=0.63 as=0.07875 ps=0.865 w=0.42 l=0.15
X69 VGND.t169 a_13646_n195.t3 a_13604_n385.t0 VGND.t168 sky130_fd_pr__nfet_01v8_lvt ad=0.1197 pd=1.41 as=0.05565 ps=0.685 w=0.42 l=0.15
X70 a_11335_n85.t1 a_10351_n435.t4 a_11037_n51.t1 VPWR.t68 sky130_fd_pr__pfet_01v8 ad=0.1428 pd=1.225 as=0.2331 ps=1.395 w=0.84 l=0.15
X71 a_7218_n1.t1 a_6306_n141.t4 a_7111_n85.t2 VPWR.t286 sky130_fd_pr__pfet_01v8 ad=0.09975 pd=0.895 as=0.1428 ps=1.225 w=0.42 l=0.15
X72 VPWR.t242 clk.t15 a_4015_n435.t0 VPWR.t241 sky130_fd_pr__pfet_01v8 ad=0.168 pd=1.42 as=0.3304 ps=2.83 w=1.12 l=0.15
X73 VGND.t266 clk.t4 a_14575_n435.t1 VGND.t265 sky130_fd_pr__nfet_01v8_lvt ad=0.1739 pd=1.21 as=0.2109 ps=2.05 w=0.74 l=0.15
X74 VGND.t338 a_15559_n85.t4 a_15758_n195.t1 VGND.t337 sky130_fd_pr__nfet_01v8_lvt ad=0.1229 pd=1.085 as=0.1824 ps=1.85 w=0.64 l=0.15
X75 VPWR.t82 a_11037_n51.t5 a_10992_n6.t0 VPWR.t81 sky130_fd_pr__pfet_01v8 ad=0.18985 pd=1.545 as=0.0504 ps=0.66 w=0.42 l=0.15
X76 VGND.t167 a_12863_n889.t4 a_13062_n999.t1 VGND.t166 sky130_fd_pr__nfet_01v8_lvt ad=0.1229 pd=1.085 as=0.1824 ps=1.85 w=0.64 l=0.15
X77 a_5362_n1188.t0 sky130_fd_sc_hs__and2_1_2.X.t4 VGND.t153 VGND.t152 sky130_fd_pr__nfet_01v8_lvt ad=0.17738 pd=1.195 as=0.33275 ps=2.31 w=0.55 l=0.15
X78 VPWR.t275 sky130_fd_sc_hs__and2_1_2.X.t6 a_5523_n945.t2 VPWR.t274 sky130_fd_pr__pfet_01v8 ad=0.2352 pd=1.54 as=0.3752 ps=2.91 w=1.12 l=0.15
X79 a_6306_n141.t0 a_6127_n435.t5 VGND.t93 VGND.t92 sky130_fd_pr__nfet_01v8_lvt ad=0.2553 pd=2.17 as=0.1739 ps=1.21 w=0.74 l=0.15
X80 a_2994_n1.t1 a_2082_n141.t4 a_2887_n85.t2 VPWR.t169 sky130_fd_pr__pfet_01v8 ad=0.09975 pd=0.895 as=0.1428 ps=1.225 w=0.42 l=0.15
X81 a_12890_n6.t0 sky130_fd_sc_hs__dfxtp_1_5.D.t4 VPWR.t200 VPWR.t199 sky130_fd_pr__pfet_01v8 ad=0.09835 pd=1.005 as=0.2972 ps=2.41 w=0.42 l=0.15
X82 sky130_fd_sc_hs__and2_1_6.B.t0 a_15758_n195.t4 VPWR.t18 VPWR.t17 sky130_fd_pr__pfet_01v8 ad=0.3304 pd=2.83 as=0.1862 ps=1.475 w=1.12 l=0.15
X83 a_15559_n85.t0 a_14754_n141.t2 a_15261_n51.t0 VGND.t36 sky130_fd_pr__nfet_01v8_lvt ad=0.1181 pd=1.035 as=0.10905 ps=1.025 w=0.55 l=0.15
X84 a_10885_n46.t1 a_10530_n141.t5 a_10778_n6.t2 VPWR.t104 sky130_fd_pr__pfet_01v8 ad=0.09835 pd=1.005 as=0.09835 ps=1.005 w=0.42 l=0.15
X85 VGND.t8 a_14975_n889.t4 a_15174_n999.t1 VGND.t7 sky130_fd_pr__nfet_01v8_lvt ad=0.1229 pd=1.085 as=0.1824 ps=1.85 w=0.64 l=0.15
X86 a_8418_n141.t1 a_8239_n435.t5 VGND.t175 VGND.t174 sky130_fd_pr__nfet_01v8_lvt ad=0.2553 pd=2.17 as=0.1739 ps=1.21 w=0.74 l=0.15
X87 a_12890_n6.t3 sky130_fd_sc_hs__dfxtp_1_5.D.t3 VGND.t317 VGND.t316 sky130_fd_pr__nfet_01v8_lvt ad=0.15563 pd=1.215 as=0.23015 ps=2.1 w=0.42 l=0.15
X88 a_6608_n1188.t0 sky130_fd_sc_hs__and2_1_3.X.t4 VGND.t63 VGND.t62 sky130_fd_pr__nfet_01v8_lvt ad=0.17738 pd=1.195 as=0.33275 ps=2.31 w=0.55 l=0.15
X89 a_7268_n385.t0 a_6127_n435.t2 a_7111_n85.t3 VGND.t302 sky130_fd_pr__nfet_01v8_lvt ad=0.05565 pd=0.685 as=0.1181 ps=1.035 w=0.42 l=0.15
X90 a_4999_n85.t3 a_4194_n141.t2 a_4701_n51.t3 VGND.t291 sky130_fd_pr__nfet_01v8_lvt ad=0.1181 pd=1.035 as=0.10905 ps=1.025 w=0.55 l=0.15
X91 sky130_fd_sc_hs__dfxtp_1_8.D.t2 a_1423_n397.t3 a_1674_n141.t1 VPWR.t321 sky130_fd_pr__pfet_01v8 ad=0.42 pd=2.99 as=0.1512 ps=1.39 w=1.12 l=0.15
X92 sky130_fd_sc_hs__xor2_1_1.X.t1 a_2872_n1188.t4 a_3033_n945.t0 VPWR.t110 sky130_fd_pr__pfet_01v8 ad=0.3864 pd=2.93 as=0.196 ps=1.47 w=1.12 l=0.15
X93 sky130_fd_sc_hs__dfxtp_1_6.D.t2 a_14095_n397.t3 a_14346_n141.t1 VPWR.t324 sky130_fd_pr__pfet_01v8 ad=0.42 pd=2.99 as=0.1512 ps=1.39 w=1.12 l=0.15
X94 a_9722_n1177.t0 sky130_fd_sc_hs__and2_1_5.X.t5 VPWR.t50 VPWR.t49 sky130_fd_pr__pfet_01v8 ad=0.147 pd=1.19 as=0.252 ps=2.28 w=0.84 l=0.15
X95 sky130_fd_sc_hs__and2_1_5.X.t0 a_8484_n1177.t3 VGND.t57 VGND.t56 sky130_fd_pr__nfet_01v8_lvt ad=0.2109 pd=2.05 as=0.15535 ps=1.17 w=0.74 l=0.15
X96 a_5362_n1188.t2 sky130_fd_sc_hs__and2_1_3.B.t7 a_5326_n921.t1 VPWR.t309 sky130_fd_pr__pfet_01v8 ad=0.295 pd=2.59 as=0.135 ps=1.27 w=1 l=0.15
X97 VPWR.t248 clk.t3 a_11879_n1239.t0 VPWR.t247 sky130_fd_pr__pfet_01v8 ad=0.168 pd=1.42 as=0.3304 ps=2.83 w=1.12 l=0.15
X98 VPWR.t171 a_7111_n85.t5 a_7310_n195.t0 VPWR.t170 sky130_fd_pr__pfet_01v8 ad=0.1862 pd=1.475 as=0.2478 ps=2.27 w=0.84 l=0.15
X99 a_15216_n6.t0 a_14575_n435.t6 a_15109_n46.t1 VPWR.t215 sky130_fd_pr__pfet_01v8 ad=0.0504 pd=0.66 as=0.09835 ps=1.005 w=0.42 l=0.15
X100 a_6813_n51.t3 a_6661_n46.t4 VGND.t288 VGND.t287 sky130_fd_pr__nfet_01v8_lvt ad=0.10905 pd=1.025 as=0.1648 ps=1.245 w=0.55 l=0.15
X101 a_4194_n141.t0 a_4015_n435.t7 VPWR.t38 VPWR.t37 sky130_fd_pr__pfet_01v8 ad=0.3304 pd=2.83 as=0.168 ps=1.42 w=1.12 l=0.15
X102 VPWR.t332 sky130_fd_sc_hs__and2_1_1.X.t6 a_4277_n945.t2 VPWR.t331 sky130_fd_pr__pfet_01v8 ad=0.2352 pd=1.54 as=0.3752 ps=2.91 w=1.12 l=0.15
X103 VGND.t147 sky130_fd_sc_hs__xor2_1_1.X.t3 a_3535_n397.t1 VGND.t146 sky130_fd_pr__nfet_01v8_lvt ad=0.15358 pd=1.2 as=0.2805 ps=2.12 w=0.55 l=0.15
X104 VPWR.t228 sky130_fd_sc_hs__xor2_1_6.X.t4 a_14095_n397.t0 VPWR.t227 sky130_fd_pr__pfet_01v8 ad=0.2345 pd=1.58 as=0.2478 ps=2.27 w=0.84 l=0.15
X105 a_9380_n385.t1 a_8239_n435.t2 a_9223_n85.t3 VGND.t320 sky130_fd_pr__nfet_01v8_lvt ad=0.05565 pd=0.685 as=0.1181 ps=1.035 w=0.42 l=0.15
X106 VPWR.t313 sky130_fd_sc_hs__xor2_1_0.X.t4 a_1423_n397.t0 VPWR.t312 sky130_fd_pr__pfet_01v8 ad=0.2345 pd=1.58 as=0.2478 ps=2.27 w=0.84 l=0.15
X107 sky130_fd_sc_hs__dfxtp_1_1.D.t1 a_3535_n397.t3 a_3786_n141.t0 VPWR.t128 sky130_fd_pr__pfet_01v8 ad=0.42 pd=2.99 as=0.1512 ps=1.39 w=1.12 l=0.15
X108 a_9361_n1226.t0 sky130_fd_sc_hs__and2_1_5.X.t3 VGND.t47 VGND.t46 sky130_fd_pr__nfet_01v8_lvt ad=0.0888 pd=0.98 as=0.12607 ps=1.1 w=0.74 l=0.15
X109 VPWR.t136 a_11534_n195.t5 a_11442_n1.t0 VPWR.t135 sky130_fd_pr__pfet_01v8 ad=0.1239 pd=1.43 as=0.09975 ps=0.895 w=0.42 l=0.15
X110 a_8925_n51.t1 a_8773_n46.t4 VGND.t26 VGND.t25 sky130_fd_pr__nfet_01v8_lvt ad=0.10905 pd=1.025 as=0.1648 ps=1.245 w=0.55 l=0.15
X111 VGND.t129 a_5647_n397.t2 sky130_fd_sc_hs__dfxtp_1_2.D.t0 VGND.t128 sky130_fd_pr__nfet_01v8_lvt ad=0.2627 pd=2.19 as=0.13135 ps=1.095 w=0.74 l=0.15
X112 VPWR.t134 a_13646_n195.t5 a_13554_n1.t1 VPWR.t133 sky130_fd_pr__pfet_01v8 ad=0.1239 pd=1.43 as=0.09975 ps=0.895 w=0.42 l=0.15
X113 a_10601_n1226.t0 sky130_fd_sc_hs__and2_1_6.X.t3 VGND.t16 VGND.t15 sky130_fd_pr__nfet_01v8_lvt ad=0.0888 pd=0.98 as=0.12607 ps=1.1 w=0.74 l=0.15
X114 sky130_fd_sc_hs__and2_1_0.X.t1 a_2254_n1177.t3 VGND.t106 VGND.t105 sky130_fd_pr__nfet_01v8_lvt ad=0.2109 pd=2.05 as=0.15535 ps=1.17 w=0.74 l=0.15
X115 a_4116_n1188.t0 sky130_fd_sc_hs__and2_1_2.B.t7 a_4080_n921.t1 VPWR.t67 sky130_fd_pr__pfet_01v8 ad=0.295 pd=2.59 as=0.135 ps=1.27 w=1 l=0.15
X116 a_4999_n85.t0 a_4015_n435.t4 a_4701_n51.t2 VPWR.t121 sky130_fd_pr__pfet_01v8 ad=0.1428 pd=1.225 as=0.2331 ps=1.395 w=0.84 l=0.15
X117 VGND.t163 a_13149_n51.t4 a_13167_n408.t1 VGND.t162 sky130_fd_pr__nfet_01v8_lvt ad=0.1648 pd=1.245 as=0.0441 ps=0.63 w=0.42 l=0.15
X118 VPWR.t246 clk.t9 a_10351_n435.t0 VPWR.t245 sky130_fd_pr__pfet_01v8 ad=0.168 pd=1.42 as=0.3304 ps=2.83 w=1.12 l=0.15
X119 VGND.t185 a_4999_n85.t4 a_5198_n195.t1 VGND.t184 sky130_fd_pr__nfet_01v8_lvt ad=0.1229 pd=1.085 as=0.1824 ps=1.85 w=0.64 l=0.15
X120 a_11650_n945.t1 rst.t3 VPWR.t266 VPWR.t265 sky130_fd_pr__pfet_01v8 ad=0.1512 pd=1.39 as=0.2345 ps=1.58 w=1.12 l=0.15
X121 sky130_fd_sc_hs__and2_1_2.X.t1 a_4746_n1177.t3 VGND.t205 VGND.t204 sky130_fd_pr__nfet_01v8_lvt ad=0.2109 pd=2.05 as=0.15535 ps=1.17 w=0.74 l=0.15
X122 VGND.t264 clk.t12 a_6127_n435.t1 VGND.t263 sky130_fd_pr__nfet_01v8_lvt ad=0.1739 pd=1.21 as=0.2109 ps=2.05 w=0.74 l=0.15
X123 sky130_fd_sc_hs__xor2_1_1.B.t1 a_5198_n195.t2 VGND.t330 VGND.t329 sky130_fd_pr__nfet_01v8_lvt ad=0.2109 pd=2.05 as=0.1229 ps=1.085 w=0.74 l=0.15
X124 VGND.t135 sky130_fd_sc_hs__xor2_1_4.B.t4 a_6608_n1188.t1 VGND.t134 sky130_fd_pr__nfet_01v8_lvt ad=0.12607 pd=1.1 as=0.17738 ps=1.195 w=0.55 l=0.15
X125 a_7111_n85.t1 a_6127_n435.t4 a_6813_n51.t1 VPWR.t99 sky130_fd_pr__pfet_01v8 ad=0.1428 pd=1.225 as=0.2331 ps=1.395 w=0.84 l=0.15
X126 a_2330_n6.t0 sky130_fd_sc_hs__dfxtp_1_8.D.t4 VPWR.t25 VPWR.t24 sky130_fd_pr__pfet_01v8 ad=0.09835 pd=1.005 as=0.2972 ps=2.41 w=0.42 l=0.15
X127 VGND.t6 a_2589_n51.t4 a_2607_n408.t0 VGND.t5 sky130_fd_pr__nfet_01v8_lvt ad=0.1648 pd=1.245 as=0.0441 ps=0.63 w=0.42 l=0.15
X128 VGND.t22 a_15261_n51.t4 a_15279_n408.t0 VGND.t21 sky130_fd_pr__nfet_01v8_lvt ad=0.1648 pd=1.245 as=0.0441 ps=0.63 w=0.42 l=0.15
X129 VPWR.t285 a_5198_n195.t5 a_5106_n1.t1 VPWR.t284 sky130_fd_pr__pfet_01v8 ad=0.1239 pd=1.43 as=0.09975 ps=0.895 w=0.42 l=0.15
X130 a_14754_n141.t0 a_14575_n435.t5 VGND.t326 VGND.t325 sky130_fd_pr__nfet_01v8_lvt ad=0.2553 pd=2.17 as=0.1739 ps=1.21 w=0.74 l=0.15
X131 sky130_fd_sc_hs__xor2_1_2.X.t0 sky130_fd_sc_hs__and2_1_2.B.t3 a_4377_n1226.t1 VGND.t296 sky130_fd_pr__nfet_01v8_lvt ad=0.1554 pd=1.16 as=0.0888 ps=0.98 w=0.74 l=0.15
X132 a_15002_n6.t2 sky130_fd_sc_hs__dfxtp_1_6.D.t3 VGND.t171 VGND.t170 sky130_fd_pr__nfet_01v8_lvt ad=0.15563 pd=1.215 as=0.23015 ps=2.1 w=0.42 l=0.15
X133 sky130_fd_sc_hs__and2_1_6.X.t1 a_9722_n1177.t3 VGND.t179 VGND.t178 sky130_fd_pr__nfet_01v8_lvt ad=0.2109 pd=2.05 as=0.15535 ps=1.17 w=0.74 l=0.15
X134 a_6769_n945.t1 sky130_fd_sc_hs__xor2_1_4.B.t6 VPWR.t32 VPWR.t31 sky130_fd_pr__pfet_01v8 ad=0.196 pd=1.47 as=0.2352 ps=1.54 w=1.12 l=0.15
X135 a_4377_n1226.t0 sky130_fd_sc_hs__and2_1_1.X.t3 VGND.t219 VGND.t218 sky130_fd_pr__nfet_01v8_lvt ad=0.0888 pd=0.98 as=0.12607 ps=1.1 w=0.74 l=0.15
X136 VPWR.t210 a_7310_n195.t5 a_7218_n1.t0 VPWR.t209 sky130_fd_pr__pfet_01v8 ad=0.1239 pd=1.43 as=0.09975 ps=0.895 w=0.42 l=0.15
X137 a_4549_n46.t3 a_4194_n141.t5 a_4442_n6.t3 VPWR.t147 sky130_fd_pr__pfet_01v8 ad=0.09835 pd=1.005 as=0.09835 ps=1.005 w=0.42 l=0.15
X138 VPWR.t187 a_15758_n195.t5 a_15666_n1.t1 VPWR.t186 sky130_fd_pr__pfet_01v8 ad=0.1239 pd=1.43 as=0.09975 ps=0.895 w=0.42 l=0.15
X139 sky130_fd_sc_hs__xor2_1_4.B.t0 a_11534_n195.t4 VPWR.t44 VPWR.t43 sky130_fd_pr__pfet_01v8 ad=0.3304 pd=2.83 as=0.1862 ps=1.475 w=1.12 l=0.15
X140 a_7111_n85.t0 a_6306_n141.t2 a_6813_n51.t0 VGND.t10 sky130_fd_pr__nfet_01v8_lvt ad=0.1181 pd=1.035 as=0.10905 ps=1.025 w=0.55 l=0.15
X141 VPWR.t292 a_2589_n51.t5 a_2544_n6.t1 VPWR.t291 sky130_fd_pr__pfet_01v8 ad=0.18985 pd=1.545 as=0.0504 ps=0.66 w=0.42 l=0.15
X142 sky130_fd_sc_hs__and2_1_4.X.t0 a_7238_n1177.t4 VPWR.t23 VPWR.t22 sky130_fd_pr__pfet_01v8 ad=0.3304 pd=2.83 as=0.1988 ps=1.505 w=1.12 l=0.15
X143 a_7854_n1188.t0 sky130_fd_sc_hs__and2_1_4.X.t4 VGND.t29 VGND.t28 sky130_fd_pr__nfet_01v8_lvt ad=0.17738 pd=1.195 as=0.33275 ps=2.31 w=0.55 l=0.15
X144 VGND.t86 a_4701_n51.t4 a_4719_n408.t1 VGND.t85 sky130_fd_pr__nfet_01v8_lvt ad=0.1648 pd=1.245 as=0.0441 ps=0.63 w=0.42 l=0.15
X145 a_6572_n921.t0 sky130_fd_sc_hs__and2_1_3.X.t7 VPWR.t9 VPWR.t8 sky130_fd_pr__pfet_01v8 ad=0.135 pd=1.27 as=0.295 ps=2.59 w=1 l=0.15
X146 VGND.t20 sky130_fd_sc_hs__and2_1_6.B.t4 a_9100_n1188.t0 VGND.t19 sky130_fd_pr__nfet_01v8_lvt ad=0.12607 pd=1.1 as=0.17738 ps=1.195 w=0.55 l=0.15
X147 VPWR.t223 a_9422_n195.t5 a_9330_n1.t1 VPWR.t222 sky130_fd_pr__pfet_01v8 ad=0.1239 pd=1.43 as=0.09975 ps=0.895 w=0.42 l=0.15
X148 a_6768_n6.t0 a_6127_n435.t6 a_6661_n46.t3 VPWR.t273 sky130_fd_pr__pfet_01v8 ad=0.0504 pd=0.66 as=0.09835 ps=1.005 w=0.42 l=0.15
X149 a_4442_n6.t2 sky130_fd_sc_hs__dfxtp_1_1.D.t3 VGND.t137 VGND.t136 sky130_fd_pr__nfet_01v8_lvt ad=0.15563 pd=1.215 as=0.23015 ps=2.1 w=0.42 l=0.15
X150 a_15716_n385.t0 a_14575_n435.t2 a_15559_n85.t3 VGND.t141 sky130_fd_pr__nfet_01v8_lvt ad=0.05565 pd=0.685 as=0.1181 ps=1.035 w=0.42 l=0.15
X151 a_10530_n141.t1 a_10351_n435.t7 VPWR.t294 VPWR.t293 sky130_fd_pr__pfet_01v8 ad=0.3304 pd=2.83 as=0.168 ps=1.42 w=1.12 l=0.15
X152 a_14632_n810.t0 a_13991_n1239.t6 a_14525_n850.t2 VPWR.t188 sky130_fd_pr__pfet_01v8 ad=0.0504 pd=0.66 as=0.09835 ps=1.005 w=0.42 l=0.15
X153 a_8015_n945.t0 sky130_fd_sc_hs__xor2_1_5.B.t6 VPWR.t64 VPWR.t63 sky130_fd_pr__pfet_01v8 ad=0.196 pd=1.47 as=0.2352 ps=1.54 w=1.12 l=0.15
X154 sky130_fd_sc_hs__xor2_1_1.X.t0 sky130_fd_sc_hs__xor2_1_1.B.t3 a_3133_n1226.t1 VGND.t232 sky130_fd_pr__nfet_01v8_lvt ad=0.1554 pd=1.16 as=0.0888 ps=0.98 w=0.74 l=0.15
X155 a_10340_n1188.t1 sky130_fd_sc_hs__and2_1_6.X.t4 VGND.t84 VGND.t83 sky130_fd_pr__nfet_01v8_lvt ad=0.17738 pd=1.195 as=0.33275 ps=2.31 w=0.55 l=0.15
X156 VPWR.t106 sky130_fd_sc_hs__and2_1_5.X.t6 a_9261_n945.t0 VPWR.t105 sky130_fd_pr__pfet_01v8 ad=0.2352 pd=1.54 as=0.3752 ps=2.91 w=1.12 l=0.15
X157 VPWR.t175 a_15559_n85.t5 a_15758_n195.t0 VPWR.t174 sky130_fd_pr__pfet_01v8 ad=0.1862 pd=1.475 as=0.2478 ps=2.27 w=0.84 l=0.15
X158 a_10122_n141.t0 rst.t9 VPWR.t262 VPWR.t261 sky130_fd_pr__pfet_01v8 ad=0.1512 pd=1.39 as=0.2345 ps=1.58 w=1.12 l=0.15
X159 VGND.t306 sky130_fd_sc_hs__and2_1_7.B.t4 a_10340_n1188.t2 VGND.t305 sky130_fd_pr__nfet_01v8_lvt ad=0.12607 pd=1.1 as=0.17738 ps=1.195 w=0.55 l=0.15
X160 VPWR.t173 sky130_fd_sc_hs__and2_1_3.B.t5 a_5990_n1177.t1 VPWR.t172 sky130_fd_pr__pfet_01v8 ad=0.1988 pd=1.505 as=0.147 ps=1.19 w=0.84 l=0.15
X161 a_15261_n51.t3 a_15109_n46.t4 VGND.t217 VGND.t216 sky130_fd_pr__nfet_01v8_lvt ad=0.10905 pd=1.025 as=0.1648 ps=1.245 w=0.55 l=0.15
X162 VGND.t139 a_7759_n397.t2 sky130_fd_sc_hs__nor2b_1_3.Y.t1 VGND.t138 sky130_fd_pr__nfet_01v8_lvt ad=0.2627 pd=2.19 as=0.13135 ps=1.095 w=0.74 l=0.15
X163 a_5523_n945.t1 sky130_fd_sc_hs__and2_1_3.B.t6 VPWR.t190 VPWR.t189 sky130_fd_pr__pfet_01v8 ad=0.196 pd=1.47 as=0.2352 ps=1.54 w=1.12 l=0.15
X164 a_13149_n51.t1 a_12997_n46.t5 VPWR.t214 VPWR.t213 sky130_fd_pr__pfet_01v8 ad=0.2331 pd=1.395 as=0.18985 ps=1.545 w=0.84 l=0.15
X165 a_4701_n51.t1 a_4549_n46.t4 VGND.t221 VGND.t220 sky130_fd_pr__nfet_01v8_lvt ad=0.10905 pd=1.025 as=0.1648 ps=1.245 w=0.55 l=0.15
X166 a_11055_n408.t0 a_10530_n141.t3 a_10885_n46.t0 VGND.t76 sky130_fd_pr__nfet_01v8_lvt ad=0.0441 pd=0.63 as=0.07875 ps=0.865 w=0.42 l=0.15
X167 a_12413_n850.t1 a_12058_n945.t5 a_12306_n810.t1 VPWR.t21 sky130_fd_pr__pfet_01v8 ad=0.09835 pd=1.005 as=0.09835 ps=1.005 w=0.42 l=0.15
X168 a_12306_n810.t3 sky130_fd_sc_hs__nor2b_1_7.Y.t4 VPWR.t103 VPWR.t102 sky130_fd_pr__pfet_01v8 ad=0.09835 pd=1.005 as=0.2972 ps=2.41 w=0.42 l=0.15
X169 sky130_fd_sc_hs__and2_1_1.X.t0 a_3502_n1177.t4 VPWR.t20 VPWR.t19 sky130_fd_pr__pfet_01v8 ad=0.3304 pd=2.83 as=0.1988 ps=1.505 w=1.12 l=0.15
X170 VGND.t260 clk.t8 a_10351_n435.t1 VGND.t259 sky130_fd_pr__nfet_01v8_lvt ad=0.1739 pd=1.21 as=0.2109 ps=2.05 w=0.74 l=0.15
X171 VPWR.t311 sky130_fd_sc_hs__and2_1_6.X.t6 a_10501_n945.t2 VPWR.t310 sky130_fd_pr__pfet_01v8 ad=0.2352 pd=1.54 as=0.3752 ps=2.91 w=1.12 l=0.15
X172 sky130_fd_sc_hs__and2_1_7.B.t1 a_13062_n999.t2 VGND.t51 VGND.t50 sky130_fd_pr__nfet_01v8_lvt ad=0.2109 pd=2.05 as=0.1229 ps=1.085 w=0.74 l=0.15
X173 a_9100_n1188.t2 sky130_fd_sc_hs__and2_1_6.B.t7 a_9064_n921.t0 VPWR.t111 sky130_fd_pr__pfet_01v8 ad=0.295 pd=2.59 as=0.135 ps=1.27 w=1 l=0.15
X174 sky130_fd_sc_hs__dfxtp_1_0.D.t2 a_13511_n1201.t3 a_13762_n945.t1 VPWR.t328 sky130_fd_pr__pfet_01v8 ad=0.42 pd=2.99 as=0.1512 ps=1.39 w=1.12 l=0.15
X175 VPWR.t290 a_15174_n999.t5 a_15082_n805.t1 VPWR.t289 sky130_fd_pr__pfet_01v8 ad=0.1239 pd=1.43 as=0.09975 ps=0.895 w=0.42 l=0.15
X176 VGND.t55 a_11534_n195.t3 a_11492_n385.t0 VGND.t54 sky130_fd_pr__nfet_01v8_lvt ad=0.1197 pd=1.41 as=0.05565 ps=0.685 w=0.42 l=0.15
X177 a_10778_n6.t0 sky130_fd_sc_hs__nor2b_1_4.Y.t4 VPWR.t86 VPWR.t85 sky130_fd_pr__pfet_01v8 ad=0.09835 pd=1.005 as=0.2972 ps=2.41 w=0.42 l=0.15
X178 a_15132_n1189.t1 a_13991_n1239.t2 a_14975_n889.t1 VGND.t140 sky130_fd_pr__nfet_01v8_lvt ad=0.05565 pd=0.685 as=0.1181 ps=1.035 w=0.42 l=0.15
X179 sky130_fd_sc_hs__xor2_1_4.X.t0 a_6608_n1188.t4 a_6769_n945.t0 VPWR.t0 sky130_fd_pr__pfet_01v8 ad=0.3864 pd=2.93 as=0.196 ps=1.47 w=1.12 l=0.15
X180 VGND.t252 clk.t6 a_12463_n435.t1 VGND.t251 sky130_fd_pr__nfet_01v8_lvt ad=0.1739 pd=1.21 as=0.2109 ps=2.05 w=0.74 l=0.15
X181 a_5898_n141.t1 rst.t13 VPWR.t264 VPWR.t263 sky130_fd_pr__pfet_01v8 ad=0.1512 pd=1.39 as=0.2345 ps=1.58 w=1.12 l=0.15
X182 a_12970_n805.t0 a_12058_n945.t4 a_12863_n889.t0 VPWR.t5 sky130_fd_pr__pfet_01v8 ad=0.09975 pd=0.895 as=0.1428 ps=1.225 w=0.42 l=0.15
X183 VPWR.t132 sky130_fd_sc_hs__and2_1_7.X.t3 a_13511_n1201.t0 VPWR.t131 sky130_fd_pr__pfet_01v8 ad=0.2345 pd=1.58 as=0.2478 ps=2.27 w=0.84 l=0.15
X184 overflow.t0 a_15174_n999.t2 VGND.t31 VGND.t30 sky130_fd_pr__nfet_01v8_lvt ad=0.2109 pd=2.05 as=0.1229 ps=1.085 w=0.74 l=0.15
X185 VGND.t74 a_13447_n85.t4 a_13646_n195.t1 VGND.t73 sky130_fd_pr__nfet_01v8_lvt ad=0.1229 pd=1.085 as=0.1824 ps=1.85 w=0.64 l=0.15
X186 VPWR.t219 sky130_fd_sc_hs__and2_1_0.B.t5 a_2254_n1177.t0 VPWR.t218 sky130_fd_pr__pfet_01v8 ad=0.1988 pd=1.505 as=0.147 ps=1.19 w=0.84 l=0.15
X187 a_4701_n51.t0 a_4549_n46.t5 VPWR.t62 VPWR.t61 sky130_fd_pr__pfet_01v8 ad=0.2331 pd=1.395 as=0.18985 ps=1.545 w=0.84 l=0.15
X188 sky130_fd_sc_hs__xor2_1_2.X.t1 a_4116_n1188.t4 a_4277_n945.t0 VPWR.t41 sky130_fd_pr__pfet_01v8 ad=0.3864 pd=2.93 as=0.196 ps=1.47 w=1.12 l=0.15
X189 a_1787_n945.t0 sky130_fd_sc_hs__and2_1_0.B.t6 VPWR.t138 VPWR.t137 sky130_fd_pr__pfet_01v8 ad=0.196 pd=1.47 as=0.2352 ps=1.54 w=1.12 l=0.15
X190 sky130_fd_sc_hs__xor2_1_5.B.t1 a_13646_n195.t2 VGND.t223 VGND.t222 sky130_fd_pr__nfet_01v8_lvt ad=0.2109 pd=2.05 as=0.1229 ps=1.085 w=0.74 l=0.15
X191 a_10340_n1188.t0 sky130_fd_sc_hs__and2_1_7.B.t7 a_10304_n921.t1 VPWR.t15 sky130_fd_pr__pfet_01v8 ad=0.295 pd=2.59 as=0.135 ps=1.27 w=1 l=0.15
X192 a_13447_n85.t3 a_12642_n141.t2 a_13149_n51.t3 VGND.t299 sky130_fd_pr__nfet_01v8_lvt ad=0.1181 pd=1.035 as=0.10905 ps=1.025 w=0.55 l=0.15
X193 VGND.t256 clk.t16 a_1903_n435.t1 VGND.t255 sky130_fd_pr__nfet_01v8_lvt ad=0.1739 pd=1.21 as=0.2109 ps=2.05 w=0.74 l=0.15
X194 a_3589_n1177.t1 sky130_fd_sc_hs__and2_1_0.X.t2 a_3502_n1177.t2 VGND.t267 sky130_fd_pr__nfet_01v8_lvt ad=0.1376 pd=1.14 as=0.1824 ps=1.85 w=0.64 l=0.15
X195 VPWR.t217 a_13149_n51.t5 a_13104_n6.t1 VPWR.t216 sky130_fd_pr__pfet_01v8 ad=0.18985 pd=1.545 as=0.0504 ps=0.66 w=0.42 l=0.15
X196 sky130_fd_sc_hs__nor2b_1_4.Y.t1 rst.t8 VGND.t277 VGND.t276 sky130_fd_pr__nfet_01v8_lvt ad=0.13135 pd=1.095 as=0.15358 ps=1.2 w=0.74 l=0.15
X197 a_1626_n1188.t2 en.t2 VGND.t247 VGND.t246 sky130_fd_pr__nfet_01v8_lvt ad=0.17738 pd=1.195 as=0.33275 ps=2.31 w=0.55 l=0.15
X198 a_8010_n141.t1 rst.t11 VPWR.t268 VPWR.t267 sky130_fd_pr__pfet_01v8 ad=0.1512 pd=1.39 as=0.2345 ps=1.58 w=1.12 l=0.15
X199 a_10778_n6.t1 sky130_fd_sc_hs__nor2b_1_4.Y.t3 VGND.t119 VGND.t118 sky130_fd_pr__nfet_01v8_lvt ad=0.15563 pd=1.215 as=0.23015 ps=2.1 w=0.42 l=0.15
X200 VPWR.t130 a_12565_n855.t5 a_12520_n810.t1 VPWR.t129 sky130_fd_pr__pfet_01v8 ad=0.18985 pd=1.545 as=0.0504 ps=0.66 w=0.42 l=0.15
X201 a_15002_n6.t0 sky130_fd_sc_hs__dfxtp_1_6.D.t4 VPWR.t98 VPWR.t97 sky130_fd_pr__pfet_01v8 ad=0.09835 pd=1.005 as=0.2972 ps=2.41 w=0.42 l=0.15
X202 sky130_fd_sc_hs__and2_1_4.X.t1 a_7238_n1177.t3 VGND.t61 VGND.t60 sky130_fd_pr__nfet_01v8_lvt ad=0.2109 pd=2.05 as=0.15535 ps=1.17 w=0.74 l=0.15
X203 VGND.t293 a_11983_n397.t2 sky130_fd_sc_hs__dfxtp_1_5.D.t2 VGND.t292 sky130_fd_pr__nfet_01v8_lvt ad=0.2627 pd=2.19 as=0.13135 ps=1.095 w=0.74 l=0.15
X204 sky130_fd_sc_hs__dfxtp_1_5.D.t0 a_11983_n397.t3 a_12234_n141.t0 VPWR.t90 sky130_fd_pr__pfet_01v8 ad=0.42 pd=2.99 as=0.1512 ps=1.39 w=1.12 l=0.15
X205 a_5156_n385.t1 a_4015_n435.t2 a_4999_n85.t2 VGND.t209 sky130_fd_pr__nfet_01v8_lvt ad=0.05565 pd=0.685 as=0.1181 ps=1.035 w=0.42 l=0.15
X206 sky130_fd_sc_hs__and2_1_0.B.t0 a_3086_n195.t4 VPWR.t168 VPWR.t167 sky130_fd_pr__pfet_01v8 ad=0.3304 pd=2.83 as=0.1862 ps=1.475 w=1.12 l=0.15
X207 a_2887_n85.t0 a_2082_n141.t2 a_2589_n51.t0 VGND.t38 sky130_fd_pr__nfet_01v8_lvt ad=0.1181 pd=1.035 as=0.10905 ps=1.025 w=0.55 l=0.15
X208 VGND.t315 sky130_fd_sc_hs__xor2_1_5.B.t2 a_8571_n1177.t1 VGND.t314 sky130_fd_pr__nfet_01v8_lvt ad=0.15535 pd=1.17 as=0.1376 ps=1.14 w=0.64 l=0.15
X209 sky130_fd_sc_hs__xor2_1_4.X.t2 sky130_fd_sc_hs__xor2_1_4.B.t3 a_6869_n1226.t1 VGND.t158 sky130_fd_pr__nfet_01v8_lvt ad=0.1554 pd=1.16 as=0.0888 ps=0.98 w=0.74 l=0.15
X210 VPWR.t323 a_4999_n85.t5 a_5198_n195.t0 VPWR.t322 sky130_fd_pr__pfet_01v8 ad=0.1862 pd=1.475 as=0.2478 ps=2.27 w=0.84 l=0.15
X211 VGND.t183 sky130_fd_sc_hs__xor2_1_6.X.t3 a_14095_n397.t1 VGND.t182 sky130_fd_pr__nfet_01v8_lvt ad=0.15358 pd=1.2 as=0.2805 ps=2.12 w=0.55 l=0.15
X212 a_8943_n408.t0 a_8418_n141.t3 a_8773_n46.t0 VGND.t109 sky130_fd_pr__nfet_01v8_lvt ad=0.0441 pd=0.63 as=0.07875 ps=0.865 w=0.42 l=0.15
X213 a_10992_n6.t1 a_10351_n435.t6 a_10885_n46.t3 VPWR.t280 sky130_fd_pr__pfet_01v8 ad=0.0504 pd=0.66 as=0.09835 ps=1.005 w=0.42 l=0.15
X214 VPWR.t336 a_14677_n855.t5 a_14632_n810.t1 VPWR.t335 sky130_fd_pr__pfet_01v8 ad=0.18985 pd=1.545 as=0.0504 ps=0.66 w=0.42 l=0.15
X215 a_3033_n945.t1 sky130_fd_sc_hs__xor2_1_1.B.t6 VPWR.t279 VPWR.t278 sky130_fd_pr__pfet_01v8 ad=0.196 pd=1.47 as=0.2352 ps=1.54 w=1.12 l=0.15
X216 a_2082_n141.t1 a_1903_n435.t7 VPWR.t304 VPWR.t303 sky130_fd_pr__pfet_01v8 ad=0.3304 pd=2.83 as=0.168 ps=1.42 w=1.12 l=0.15
X217 a_6869_n1226.t0 sky130_fd_sc_hs__and2_1_3.X.t3 VGND.t1 VGND.t0 sky130_fd_pr__nfet_01v8_lvt ad=0.0888 pd=0.98 as=0.12607 ps=1.1 w=0.74 l=0.15
X218 VGND.t332 sky130_fd_sc_hs__xor2_1_0.X.t3 a_1423_n397.t1 VGND.t331 sky130_fd_pr__nfet_01v8_lvt ad=0.15358 pd=1.2 as=0.2805 ps=2.12 w=0.55 l=0.15
X219 VGND.t121 a_1423_n397.t2 sky130_fd_sc_hs__dfxtp_1_8.D.t0 VGND.t120 sky130_fd_pr__nfet_01v8_lvt ad=0.2627 pd=2.19 as=0.13135 ps=1.095 w=0.74 l=0.15
X220 VPWR.t46 sky130_fd_sc_hs__xor2_1_5.X.t4 a_11983_n397.t0 VPWR.t45 sky130_fd_pr__pfet_01v8 ad=0.2345 pd=1.58 as=0.2478 ps=2.27 w=0.84 l=0.15
X221 VGND.t235 a_14095_n397.t2 sky130_fd_sc_hs__dfxtp_1_6.D.t0 VGND.t234 sky130_fd_pr__nfet_01v8_lvt ad=0.2627 pd=2.19 as=0.13135 ps=1.095 w=0.74 l=0.15
X222 sky130_fd_sc_hs__nor2b_1_7.Y.t2 rst.t2 VGND.t275 VGND.t274 sky130_fd_pr__nfet_01v8_lvt ad=0.13135 pd=1.095 as=0.15358 ps=1.2 w=0.74 l=0.15
X223 a_13447_n85.t0 a_12463_n435.t4 a_13149_n51.t0 VPWR.t16 sky130_fd_pr__pfet_01v8 ad=0.1428 pd=1.225 as=0.2331 ps=1.395 w=0.84 l=0.15
X224 sky130_fd_sc_hs__and2_1_3.B.t1 a_9422_n195.t4 VPWR.t283 VPWR.t282 sky130_fd_pr__pfet_01v8 ad=0.3304 pd=2.83 as=0.1862 ps=1.475 w=1.12 l=0.15
X225 sky130_fd_sc_hs__xor2_1_6.X.t0 sky130_fd_sc_hs__and2_1_6.B.t3 a_9361_n1226.t1 VGND.t72 sky130_fd_pr__nfet_01v8_lvt ad=0.1554 pd=1.16 as=0.0888 ps=0.98 w=0.74 l=0.15
X226 VPWR.t183 sky130_fd_sc_hs__xor2_1_5.B.t5 a_8484_n1177.t2 VPWR.t182 sky130_fd_pr__pfet_01v8 ad=0.1988 pd=1.505 as=0.147 ps=1.19 w=0.84 l=0.15
X227 VGND.t113 a_3535_n397.t2 sky130_fd_sc_hs__dfxtp_1_1.D.t0 VGND.t112 sky130_fd_pr__nfet_01v8_lvt ad=0.2627 pd=2.19 as=0.13135 ps=1.095 w=0.74 l=0.15
X228 VGND.t192 sky130_fd_sc_hs__and2_1_0.B.t2 a_2341_n1177.t0 VGND.t191 sky130_fd_pr__nfet_01v8_lvt ad=0.15535 pd=1.17 as=0.1376 ps=1.14 w=0.64 l=0.15
X229 sky130_fd_sc_hs__dfxtp_1_0.D.t1 rst.t0 VGND.t279 VGND.t278 sky130_fd_pr__nfet_01v8_lvt ad=0.13135 pd=1.095 as=0.15358 ps=1.2 w=0.74 l=0.15
X230 sky130_fd_sc_hs__nor2b_1_7.B_N.t1 sky130_fd_sc_hs__and2_1_7.B.t3 a_10601_n1226.t1 VGND.t104 sky130_fd_pr__nfet_01v8_lvt ad=0.1554 pd=1.16 as=0.0888 ps=0.98 w=0.74 l=0.15
X231 a_12997_n46.t2 a_12642_n141.t5 a_12890_n6.t1 VPWR.t201 sky130_fd_pr__pfet_01v8 ad=0.09835 pd=1.005 as=0.09835 ps=1.005 w=0.42 l=0.15
X232 a_15082_n805.t0 a_14170_n945.t4 a_14975_n889.t2 VPWR.t197 sky130_fd_pr__pfet_01v8 ad=0.09975 pd=0.895 as=0.1428 ps=1.225 w=0.42 l=0.15
X233 sky130_fd_sc_hs__xor2_1_0.X.t0 a_1626_n1188.t4 a_1787_n945.t1 VPWR.t194 sky130_fd_pr__pfet_01v8 ad=0.3864 pd=2.93 as=0.196 ps=1.47 w=1.12 l=0.15
X234 sky130_fd_sc_hs__nor2b_1_3.Y.t2 rst.t10 VGND.t273 VGND.t272 sky130_fd_pr__nfet_01v8_lvt ad=0.13135 pd=1.095 as=0.15358 ps=1.2 w=0.74 l=0.15
X235 VGND.t190 a_3086_n195.t3 a_3044_n385.t0 VGND.t189 sky130_fd_pr__nfet_01v8_lvt ad=0.1197 pd=1.41 as=0.05565 ps=0.685 w=0.42 l=0.15
X236 VGND.t131 sky130_fd_sc_hs__and2_1_0.B.t4 a_1626_n1188.t0 VGND.t130 sky130_fd_pr__nfet_01v8_lvt ad=0.12607 pd=1.1 as=0.17738 ps=1.195 w=0.55 l=0.15
X237 VGND.t341 sky130_fd_sc_hs__xor2_1_1.B.t4 a_2872_n1188.t2 VGND.t340 sky130_fd_pr__nfet_01v8_lvt ad=0.12607 pd=1.1 as=0.17738 ps=1.195 w=0.55 l=0.15
X238 sky130_fd_sc_hs__and2_1_6.B.t1 a_15758_n195.t2 VGND.t123 VGND.t122 sky130_fd_pr__nfet_01v8_lvt ad=0.2109 pd=2.05 as=0.1229 ps=1.085 w=0.74 l=0.15
X239 VPWR.t272 sky130_fd_sc_hs__xor2_1_3.X.t4 a_7759_n397.t0 VPWR.t271 sky130_fd_pr__pfet_01v8 ad=0.2345 pd=1.58 as=0.2478 ps=2.27 w=0.84 l=0.15
X240 VGND.t250 clk.t14 a_4015_n435.t1 VGND.t249 sky130_fd_pr__nfet_01v8_lvt ad=0.1739 pd=1.21 as=0.2109 ps=2.05 w=0.74 l=0.15
X241 VPWR.t48 sky130_fd_sc_hs__xor2_1_4.B.t5 a_7238_n1177.t1 VPWR.t47 sky130_fd_pr__pfet_01v8 ad=0.1988 pd=1.505 as=0.147 ps=1.19 w=0.84 l=0.15
X242 VPWR.t158 a_4701_n51.t5 a_4656_n6.t1 VPWR.t157 sky130_fd_pr__pfet_01v8 ad=0.18985 pd=1.545 as=0.0504 ps=0.66 w=0.42 l=0.15
X243 VGND.t18 a_13062_n999.t3 a_13020_n1189.t0 VGND.t17 sky130_fd_pr__nfet_01v8_lvt ad=0.1197 pd=1.41 as=0.05565 ps=0.685 w=0.42 l=0.15
X244 a_12642_n141.t1 a_12463_n435.t5 VGND.t200 VGND.t199 sky130_fd_pr__nfet_01v8_lvt ad=0.2553 pd=2.17 as=0.1739 ps=1.21 w=0.74 l=0.15
X245 a_2872_n1188.t1 sky130_fd_sc_hs__and2_1_0.X.t4 VGND.t215 VGND.t214 sky130_fd_pr__nfet_01v8_lvt ad=0.17738 pd=1.195 as=0.33275 ps=2.31 w=0.55 l=0.15
X246 a_14677_n855.t0 a_14525_n850.t5 VPWR.t155 VPWR.t154 sky130_fd_pr__pfet_01v8 ad=0.2331 pd=1.395 as=0.18985 ps=1.545 w=0.84 l=0.15
X247 VPWR.t66 sky130_fd_sc_hs__xor2_1_4.X.t4 a_9871_n397.t0 VPWR.t65 sky130_fd_pr__pfet_01v8 ad=0.2345 pd=1.58 as=0.2478 ps=2.27 w=0.84 l=0.15
X248 a_4442_n6.t1 sky130_fd_sc_hs__dfxtp_1_1.D.t4 VPWR.t89 VPWR.t88 sky130_fd_pr__pfet_01v8 ad=0.09835 pd=1.005 as=0.2972 ps=2.41 w=0.42 l=0.15
X249 a_12863_n889.t1 a_12058_n945.t2 a_12565_n855.t0 VGND.t27 sky130_fd_pr__nfet_01v8_lvt ad=0.1181 pd=1.035 as=0.10905 ps=1.025 w=0.55 l=0.15
X250 VGND.t133 a_5362_n1188.t3 sky130_fd_sc_hs__xor2_1_3.X.t1 VGND.t132 sky130_fd_pr__nfet_01v8_lvt ad=0.2997 pd=2.29 as=0.1554 ps=1.16 w=0.74 l=0.15
X251 VGND.t91 a_15174_n999.t3 a_15132_n1189.t0 VGND.t90 sky130_fd_pr__nfet_01v8_lvt ad=0.1197 pd=1.41 as=0.05565 ps=0.685 w=0.42 l=0.15
X252 VGND.t345 a_6608_n1188.t3 sky130_fd_sc_hs__xor2_1_4.X.t1 VGND.t344 sky130_fd_pr__nfet_01v8_lvt ad=0.2997 pd=2.29 as=0.1554 ps=1.16 w=0.74 l=0.15
X253 VPWR.t225 a_11335_n85.t5 a_11534_n195.t0 VPWR.t224 sky130_fd_pr__pfet_01v8 ad=0.1862 pd=1.475 as=0.2478 ps=2.27 w=0.84 l=0.15
X254 a_2330_n6.t3 sky130_fd_sc_hs__dfxtp_1_8.D.t3 VGND.t311 VGND.t310 sky130_fd_pr__nfet_01v8_lvt ad=0.15563 pd=1.215 as=0.23015 ps=2.1 w=0.42 l=0.15
X255 a_13604_n385.t1 a_12463_n435.t2 a_13447_n85.t2 VGND.t231 sky130_fd_pr__nfet_01v8_lvt ad=0.05565 pd=0.685 as=0.1181 ps=1.035 w=0.42 l=0.15
X256 a_15109_n46.t0 a_14754_n141.t5 a_15002_n6.t1 VPWR.t107 sky130_fd_pr__pfet_01v8 ad=0.09835 pd=1.005 as=0.09835 ps=1.005 w=0.42 l=0.15
X257 a_14975_n889.t0 a_14170_n945.t2 a_14677_n855.t2 VGND.t58 sky130_fd_pr__nfet_01v8_lvt ad=0.1181 pd=1.035 as=0.10905 ps=1.025 w=0.55 l=0.15
X258 VPWR.t252 clk.t1 a_13991_n1239.t0 VPWR.t251 sky130_fd_pr__pfet_01v8 ad=0.168 pd=1.42 as=0.3304 ps=2.83 w=1.12 l=0.15
X259 VPWR.t178 a_13447_n85.t5 a_13646_n195.t0 VPWR.t177 sky130_fd_pr__pfet_01v8 ad=0.1862 pd=1.475 as=0.2478 ps=2.27 w=0.84 l=0.15
X260 a_13149_n51.t2 a_12997_n46.t4 VGND.t143 VGND.t142 sky130_fd_pr__nfet_01v8_lvt ad=0.10905 pd=1.025 as=0.1648 ps=1.245 w=0.55 l=0.15
X261 VGND.t71 a_7854_n1188.t3 sky130_fd_sc_hs__xor2_1_5.X.t1 VGND.t70 sky130_fd_pr__nfet_01v8_lvt ad=0.2997 pd=2.29 as=0.1554 ps=1.16 w=0.74 l=0.15
X262 a_5990_n1177.t0 sky130_fd_sc_hs__and2_1_2.X.t5 VPWR.t166 VPWR.t165 sky130_fd_pr__pfet_01v8 ad=0.147 pd=1.19 as=0.252 ps=2.28 w=0.84 l=0.15
X263 a_6661_n46.t1 a_6306_n141.t5 a_6554_n6.t2 VPWR.t181 sky130_fd_pr__pfet_01v8 ad=0.09835 pd=1.005 as=0.09835 ps=1.005 w=0.42 l=0.15
X264 a_12306_n810.t2 sky130_fd_sc_hs__nor2b_1_7.Y.t3 VGND.t95 VGND.t94 sky130_fd_pr__nfet_01v8_lvt ad=0.15563 pd=1.215 as=0.23015 ps=2.1 w=0.42 l=0.15
X265 sky130_fd_sc_hs__and2_1_7.B.t0 a_13062_n999.t4 VPWR.t76 VPWR.t75 sky130_fd_pr__pfet_01v8 ad=0.3304 pd=2.83 as=0.1862 ps=1.475 w=1.12 l=0.15
X266 a_2589_n51.t3 a_2437_n46.t4 VGND.t196 VGND.t195 sky130_fd_pr__nfet_01v8_lvt ad=0.10905 pd=1.025 as=0.1648 ps=1.245 w=0.55 l=0.15
X267 a_7854_n1188.t2 sky130_fd_sc_hs__xor2_1_5.B.t7 a_7818_n921.t1 VPWR.t156 sky130_fd_pr__pfet_01v8 ad=0.295 pd=2.59 as=0.135 ps=1.27 w=1 l=0.15
X268 a_12058_n945.t0 a_11879_n1239.t7 VPWR.t70 VPWR.t69 sky130_fd_pr__pfet_01v8 ad=0.3304 pd=2.83 as=0.168 ps=1.42 w=1.12 l=0.15
X269 a_9223_n85.t1 a_8239_n435.t4 a_8925_n51.t2 VPWR.t179 sky130_fd_pr__pfet_01v8 ad=0.1428 pd=1.225 as=0.2331 ps=1.395 w=0.84 l=0.15
X270 a_14525_n850.t1 a_13991_n1239.t3 a_14418_n810.t1 VGND.t188 sky130_fd_pr__nfet_01v8_lvt ad=0.07875 pd=0.865 as=0.15563 ps=1.215 w=0.42 l=0.15
X271 VPWR.t277 sky130_fd_sc_hs__and2_1_3.X.t6 a_6769_n945.t2 VPWR.t276 sky130_fd_pr__pfet_01v8 ad=0.2352 pd=1.54 as=0.3752 ps=2.91 w=1.12 l=0.15
X272 a_15109_n46.t2 a_14575_n435.t3 a_15002_n6.t3 VGND.t237 sky130_fd_pr__nfet_01v8_lvt ad=0.07875 pd=0.865 as=0.15563 ps=1.215 w=0.42 l=0.15
X273 a_14418_n810.t3 sky130_fd_sc_hs__dfxtp_1_0.D.t3 VGND.t322 VGND.t321 sky130_fd_pr__nfet_01v8_lvt ad=0.15563 pd=1.215 as=0.23015 ps=2.1 w=0.42 l=0.15
X274 overflow.t1 a_15174_n999.t4 VPWR.t151 VPWR.t150 sky130_fd_pr__pfet_01v8 ad=0.3304 pd=2.83 as=0.1862 ps=1.475 w=1.12 l=0.15
X275 a_9809_n1177.t1 sky130_fd_sc_hs__and2_1_5.X.t2 a_9722_n1177.t2 VGND.t233 sky130_fd_pr__nfet_01v8_lvt ad=0.1376 pd=1.14 as=0.1824 ps=1.85 w=0.64 l=0.15
X276 sky130_fd_sc_hs__nor2b_1_7.Y.t1 a_11399_n1201.t3 a_11650_n945.t0 VPWR.t226 sky130_fd_pr__pfet_01v8 ad=0.42 pd=2.99 as=0.1512 ps=1.39 w=1.12 l=0.15
X277 a_14346_n141.t0 rst.t5 VPWR.t270 VPWR.t269 sky130_fd_pr__pfet_01v8 ad=0.1512 pd=1.39 as=0.2345 ps=1.58 w=1.12 l=0.15
X278 a_5326_n921.t0 sky130_fd_sc_hs__and2_1_2.X.t7 VPWR.t84 VPWR.t83 sky130_fd_pr__pfet_01v8 ad=0.135 pd=1.27 as=0.295 ps=2.59 w=1 l=0.15
X279 VPWR.t72 a_13062_n999.t5 a_12970_n805.t1 VPWR.t71 sky130_fd_pr__pfet_01v8 ad=0.1239 pd=1.43 as=0.09975 ps=0.895 w=0.42 l=0.15
X280 a_14170_n945.t1 a_13991_n1239.t7 VPWR.t326 VPWR.t325 sky130_fd_pr__pfet_01v8 ad=0.3304 pd=2.83 as=0.168 ps=1.42 w=1.12 l=0.15
X281 VPWR.t78 sky130_fd_sc_hs__nor2b_1_7.B_N.t4 a_11399_n1201.t0 VPWR.t77 sky130_fd_pr__pfet_01v8 ad=0.2345 pd=1.58 as=0.2478 ps=2.27 w=0.84 l=0.15
X282 VGND.t290 sky130_fd_sc_hs__and2_1_2.B.t2 a_4833_n1177.t1 VGND.t289 sky130_fd_pr__nfet_01v8_lvt ad=0.15535 pd=1.17 as=0.1376 ps=1.14 w=0.64 l=0.15
X283 a_4549_n46.t0 a_4015_n435.t3 a_4442_n6.t0 VGND.t4 sky130_fd_pr__nfet_01v8_lvt ad=0.07875 pd=0.865 as=0.15563 ps=1.215 w=0.42 l=0.15
X284 VGND.t343 a_11335_n85.t4 a_11534_n195.t1 VGND.t342 sky130_fd_pr__nfet_01v8_lvt ad=0.1229 pd=1.085 as=0.1824 ps=1.85 w=0.64 l=0.15
X285 a_3786_n141.t1 rst.t15 VPWR.t254 VPWR.t253 sky130_fd_pr__pfet_01v8 ad=0.1512 pd=1.39 as=0.2345 ps=1.58 w=1.12 l=0.15
X286 a_12565_n855.t2 a_12413_n850.t4 VGND.t49 VGND.t48 sky130_fd_pr__nfet_01v8_lvt ad=0.10905 pd=1.025 as=0.1648 ps=1.245 w=0.55 l=0.15
X287 sky130_fd_sc_hs__and2_1_6.X.t0 a_9722_n1177.t4 VPWR.t164 VPWR.t163 sky130_fd_pr__pfet_01v8 ad=0.3304 pd=2.83 as=0.1988 ps=1.505 w=1.12 l=0.15
X288 a_6077_n1177.t1 sky130_fd_sc_hs__and2_1_2.X.t2 a_5990_n1177.t2 VGND.t226 sky130_fd_pr__nfet_01v8_lvt ad=0.1376 pd=1.14 as=0.1824 ps=1.85 w=0.64 l=0.15
X289 a_6608_n1188.t2 sky130_fd_sc_hs__xor2_1_4.B.t7 a_6572_n921.t1 VPWR.t193 sky130_fd_pr__pfet_01v8 ad=0.295 pd=2.59 as=0.135 ps=1.27 w=1 l=0.15
X290 a_2254_n1177.t1 en.t3 VPWR.t232 VPWR.t231 sky130_fd_pr__pfet_01v8 ad=0.147 pd=1.19 as=0.252 ps=2.28 w=0.84 l=0.15
X291 sky130_fd_sc_hs__xor2_1_4.B.t1 a_11534_n195.t2 VGND.t53 VGND.t52 sky130_fd_pr__nfet_01v8_lvt ad=0.2109 pd=2.05 as=0.1229 ps=1.085 w=0.74 l=0.15
X292 a_4277_n945.t1 sky130_fd_sc_hs__and2_1_2.B.t6 VPWR.t125 VPWR.t124 sky130_fd_pr__pfet_01v8 ad=0.196 pd=1.47 as=0.2352 ps=1.54 w=1.12 l=0.15
X293 a_11335_n85.t0 a_10530_n141.t2 a_11037_n51.t0 VGND.t75 sky130_fd_pr__nfet_01v8_lvt ad=0.1181 pd=1.035 as=0.10905 ps=1.025 w=0.55 l=0.15
X294 a_4194_n141.t1 a_4015_n435.t5 VGND.t228 VGND.t227 sky130_fd_pr__nfet_01v8_lvt ad=0.2553 pd=2.17 as=0.1739 ps=1.21 w=0.74 l=0.15
X295 a_14677_n855.t1 a_14525_n850.t4 VGND.t69 VGND.t68 sky130_fd_pr__nfet_01v8_lvt ad=0.10905 pd=1.025 as=0.1648 ps=1.245 w=0.55 l=0.15
X296 VGND.t198 sky130_fd_sc_hs__xor2_1_4.B.t2 a_7325_n1177.t1 VGND.t197 sky130_fd_pr__nfet_01v8_lvt ad=0.15535 pd=1.17 as=0.1376 ps=1.14 w=0.64 l=0.15
X297 VGND.t239 sky130_fd_sc_hs__xor2_1_1.B.t2 a_3589_n1177.t0 VGND.t238 sky130_fd_pr__nfet_01v8_lvt ad=0.15535 pd=1.17 as=0.1376 ps=1.14 w=0.64 l=0.15
X298 sky130_fd_sc_hs__xor2_1_0.X.t2 sky130_fd_sc_hs__and2_1_0.B.t3 a_1887_n1226.t1 VGND.t286 sky130_fd_pr__nfet_01v8_lvt ad=0.1554 pd=1.16 as=0.0888 ps=0.98 w=0.74 l=0.15
X299 a_15261_n51.t2 a_15109_n46.t5 VPWR.t298 VPWR.t297 sky130_fd_pr__pfet_01v8 ad=0.2331 pd=1.395 as=0.18985 ps=1.545 w=0.84 l=0.15
X300 a_11442_n1.t1 a_10530_n141.t4 a_11335_n85.t3 VPWR.t318 sky130_fd_pr__pfet_01v8 ad=0.09975 pd=0.895 as=0.1428 ps=1.225 w=0.42 l=0.15
X301 sky130_fd_sc_hs__nor2b_1_4.Y.t2 a_9871_n397.t3 a_10122_n141.t1 VPWR.t281 sky130_fd_pr__pfet_01v8 ad=0.42 pd=2.99 as=0.1512 ps=1.39 w=1.12 l=0.15
X302 VPWR.t288 a_15261_n51.t5 a_15216_n6.t1 VPWR.t287 sky130_fd_pr__pfet_01v8 ad=0.18985 pd=1.545 as=0.0504 ps=0.66 w=0.42 l=0.15
X303 a_3044_n385.t1 a_1903_n435.t2 a_2887_n85.t3 VGND.t240 sky130_fd_pr__nfet_01v8_lvt ad=0.05565 pd=0.685 as=0.1181 ps=1.035 w=0.42 l=0.15
X304 a_1887_n1226.t0 en.t1 VGND.t245 VGND.t244 sky130_fd_pr__nfet_01v8_lvt ad=0.0888 pd=0.98 as=0.12607 ps=1.1 w=0.74 l=0.15
X305 sky130_fd_sc_hs__and2_1_7.X.t0 a_10950_n1177.t4 VPWR.t4 VPWR.t3 sky130_fd_pr__pfet_01v8 ad=0.3304 pd=2.83 as=0.1988 ps=1.505 w=1.12 l=0.15
X306 a_3133_n1226.t0 sky130_fd_sc_hs__and2_1_0.X.t3 VGND.t181 VGND.t180 sky130_fd_pr__nfet_01v8_lvt ad=0.0888 pd=0.98 as=0.12607 ps=1.1 w=0.74 l=0.15
X307 sky130_fd_sc_hs__and2_1_1.X.t1 a_3502_n1177.t3 VGND.t334 VGND.t333 sky130_fd_pr__nfet_01v8_lvt ad=0.2109 pd=2.05 as=0.15535 ps=1.17 w=0.74 l=0.15
X308 a_13554_n1.t0 a_12642_n141.t4 a_13447_n85.t1 VPWR.t118 sky130_fd_pr__pfet_01v8 ad=0.09975 pd=0.895 as=0.1428 ps=1.225 w=0.42 l=0.15
X309 a_1590_n921.t1 en.t5 VPWR.t230 VPWR.t229 sky130_fd_pr__pfet_01v8 ad=0.135 pd=1.27 as=0.295 ps=2.59 w=1 l=0.15
X310 VGND.t309 sky130_fd_sc_hs__xor2_1_5.X.t3 a_11983_n397.t1 VGND.t308 sky130_fd_pr__nfet_01v8_lvt ad=0.15358 pd=1.2 as=0.2805 ps=2.12 w=0.55 l=0.15
X311 a_6831_n408.t1 a_6306_n141.t3 a_6661_n46.t0 VGND.t40 sky130_fd_pr__nfet_01v8_lvt ad=0.0441 pd=0.63 as=0.07875 ps=0.865 w=0.42 l=0.15
X312 a_6813_n51.t2 a_6661_n46.t5 VPWR.t320 VPWR.t319 sky130_fd_pr__pfet_01v8 ad=0.2331 pd=1.395 as=0.18985 ps=1.545 w=0.84 l=0.15
X313 VPWR.t244 clk.t11 a_8239_n435.t0 VPWR.t243 sky130_fd_pr__pfet_01v8 ad=0.168 pd=1.42 as=0.3304 ps=2.83 w=1.12 l=0.15
X314 VGND.t324 a_9100_n1188.t3 sky130_fd_sc_hs__xor2_1_6.X.t2 VGND.t323 sky130_fd_pr__nfet_01v8_lvt ad=0.2997 pd=2.29 as=0.1554 ps=1.16 w=0.74 l=0.15
X315 VPWR.t58 a_3086_n195.t5 a_2994_n1.t0 VPWR.t57 sky130_fd_pr__pfet_01v8 ad=0.1239 pd=1.43 as=0.09975 ps=0.895 w=0.42 l=0.15
X316 a_15666_n1.t0 a_14754_n141.t4 a_15559_n85.t2 VPWR.t113 sky130_fd_pr__pfet_01v8 ad=0.09975 pd=0.895 as=0.1428 ps=1.225 w=0.42 l=0.15
X317 sky130_fd_sc_hs__dfxtp_1_6.D.t1 rst.t4 VGND.t271 VGND.t270 sky130_fd_pr__nfet_01v8_lvt ad=0.13135 pd=1.095 as=0.15358 ps=1.2 w=0.74 l=0.15
X318 a_11037_n1177.t0 sky130_fd_sc_hs__and2_1_6.X.t2 a_10950_n1177.t0 VGND.t3 sky130_fd_pr__nfet_01v8_lvt ad=0.1376 pd=1.14 as=0.1824 ps=1.85 w=0.64 l=0.15
X319 sky130_fd_sc_hs__and2_1_2.B.t1 a_7310_n195.t4 VPWR.t203 VPWR.t202 sky130_fd_pr__pfet_01v8 ad=0.3304 pd=2.83 as=0.1862 ps=1.475 w=1.12 l=0.15
X320 VGND.t24 a_10340_n1188.t3 sky130_fd_sc_hs__nor2b_1_7.B_N.t0 VGND.t23 sky130_fd_pr__nfet_01v8_lvt ad=0.2997 pd=2.29 as=0.1554 ps=1.16 w=0.74 l=0.15
X321 a_8484_n1177.t1 sky130_fd_sc_hs__and2_1_4.X.t5 VPWR.t80 VPWR.t79 sky130_fd_pr__pfet_01v8 ad=0.147 pd=1.19 as=0.252 ps=2.28 w=0.84 l=0.15
X322 sky130_fd_sc_hs__dfxtp_1_1.D.t2 rst.t14 VGND.t269 VGND.t268 sky130_fd_pr__nfet_01v8_lvt ad=0.13135 pd=1.095 as=0.15358 ps=1.2 w=0.74 l=0.15
X323 a_10885_n46.t2 a_10351_n435.t3 a_10778_n6.t3 VGND.t161 sky130_fd_pr__nfet_01v8_lvt ad=0.07875 pd=0.865 as=0.15563 ps=1.215 w=0.42 l=0.15
X324 a_8418_n141.t0 a_8239_n435.t7 VPWR.t28 VPWR.t27 sky130_fd_pr__pfet_01v8 ad=0.3304 pd=2.83 as=0.168 ps=1.42 w=1.12 l=0.15
X325 sky130_fd_sc_hs__dfxtp_1_2.D.t2 rst.t12 VGND.t283 VGND.t282 sky130_fd_pr__nfet_01v8_lvt ad=0.13135 pd=1.095 as=0.15358 ps=1.2 w=0.74 l=0.15
X326 a_8925_n51.t0 a_8773_n46.t5 VPWR.t101 VPWR.t100 sky130_fd_pr__pfet_01v8 ad=0.2331 pd=1.395 as=0.18985 ps=1.545 w=0.84 l=0.15
X327 VPWR.t221 sky130_fd_sc_hs__xor2_1_2.X.t4 a_5647_n397.t0 VPWR.t220 sky130_fd_pr__pfet_01v8 ad=0.2345 pd=1.58 as=0.2478 ps=2.27 w=0.84 l=0.15
X328 VGND.t80 a_11037_n51.t4 a_11055_n408.t1 VGND.t79 sky130_fd_pr__nfet_01v8_lvt ad=0.1648 pd=1.245 as=0.0441 ps=0.63 w=0.42 l=0.15
X329 a_9330_n1.t0 a_8418_n141.t4 a_9223_n85.t0 VPWR.t176 sky130_fd_pr__pfet_01v8 ad=0.09975 pd=0.895 as=0.1428 ps=1.225 w=0.42 l=0.15
X330 VGND.t213 a_2887_n85.t4 a_3086_n195.t1 VGND.t212 sky130_fd_pr__nfet_01v8_lvt ad=0.1229 pd=1.085 as=0.1824 ps=1.85 w=0.64 l=0.15
X331 VGND.t127 a_4116_n1188.t3 sky130_fd_sc_hs__xor2_1_2.X.t2 VGND.t126 sky130_fd_pr__nfet_01v8_lvt ad=0.2997 pd=2.29 as=0.1554 ps=1.16 w=0.74 l=0.15
X332 a_10530_n141.t0 a_10351_n435.t5 VGND.t125 VGND.t124 sky130_fd_pr__nfet_01v8_lvt ad=0.2553 pd=2.17 as=0.1739 ps=1.21 w=0.74 l=0.15
X333 a_7238_n1177.t2 sky130_fd_sc_hs__and2_1_3.X.t5 VPWR.t123 VPWR.t122 sky130_fd_pr__pfet_01v8 ad=0.147 pd=1.19 as=0.252 ps=2.28 w=0.84 l=0.15
X334 VGND.t194 sky130_fd_sc_hs__xor2_1_4.X.t3 a_9871_n397.t1 VGND.t193 sky130_fd_pr__nfet_01v8_lvt ad=0.15358 pd=1.2 as=0.2805 ps=2.12 w=0.55 l=0.15
X335 sky130_fd_sc_hs__and2_1_0.B.t1 a_3086_n195.t2 VGND.t328 VGND.t327 sky130_fd_pr__nfet_01v8_lvt ad=0.2109 pd=2.05 as=0.1229 ps=1.085 w=0.74 l=0.15
X336 VPWR.t308 a_6813_n51.t5 a_6768_n6.t1 VPWR.t307 sky130_fd_pr__pfet_01v8 ad=0.18985 pd=1.545 as=0.0504 ps=0.66 w=0.42 l=0.15
X337 a_15559_n85.t1 a_14575_n435.t4 a_15261_n51.t1 VPWR.t26 sky130_fd_pr__pfet_01v8 ad=0.1428 pd=1.225 as=0.2331 ps=1.395 w=0.84 l=0.15
X338 sky130_fd_sc_hs__xor2_1_6.X.t1 a_9100_n1188.t4 a_9261_n945.t2 VPWR.t205 sky130_fd_pr__pfet_01v8 ad=0.3864 pd=2.93 as=0.196 ps=1.47 w=1.12 l=0.15
X339 VPWR.t208 sky130_fd_sc_hs__and2_1_2.B.t5 a_4746_n1177.t1 VPWR.t207 sky130_fd_pr__pfet_01v8 ad=0.1988 pd=1.505 as=0.147 ps=1.19 w=0.84 l=0.15
X340 a_11492_n385.t1 a_10351_n435.t2 a_11335_n85.t2 VGND.t206 sky130_fd_pr__nfet_01v8_lvt ad=0.05565 pd=0.685 as=0.1181 ps=1.035 w=0.42 l=0.15
X341 a_6554_n6.t0 sky130_fd_sc_hs__dfxtp_1_2.D.t4 VPWR.t120 VPWR.t119 sky130_fd_pr__pfet_01v8 ad=0.09835 pd=1.005 as=0.2972 ps=2.41 w=0.42 l=0.15
X342 VPWR.t250 clk.t5 a_14575_n435.t0 VPWR.t249 sky130_fd_pr__pfet_01v8 ad=0.168 pd=1.42 as=0.3304 ps=2.83 w=1.12 l=0.15
X343 VGND.t45 a_2872_n1188.t3 sky130_fd_sc_hs__xor2_1_1.X.t2 VGND.t44 sky130_fd_pr__nfet_01v8_lvt ad=0.2997 pd=2.29 as=0.1554 ps=1.16 w=0.74 l=0.15
X344 VGND.t151 a_9422_n195.t3 a_9380_n385.t0 VGND.t150 sky130_fd_pr__nfet_01v8_lvt ad=0.1197 pd=1.41 as=0.05565 ps=0.685 w=0.42 l=0.15
X345 a_11037_n51.t3 a_10885_n46.t4 VGND.t82 VGND.t81 sky130_fd_pr__nfet_01v8_lvt ad=0.10905 pd=1.025 as=0.1648 ps=1.245 w=0.55 l=0.15
X346 a_2544_n6.t0 a_1903_n435.t6 a_2437_n46.t2 VPWR.t144 sky130_fd_pr__pfet_01v8 ad=0.0504 pd=0.66 as=0.09835 ps=1.005 w=0.42 l=0.15
X347 a_12520_n810.t0 a_11879_n1239.t6 a_12413_n850.t3 VPWR.t112 sky130_fd_pr__pfet_01v8 ad=0.0504 pd=0.66 as=0.09835 ps=1.005 w=0.42 l=0.15
X348 sky130_fd_sc_hs__nor2b_1_7.B_N.t2 a_10340_n1188.t4 a_10501_n945.t1 VPWR.t139 sky130_fd_pr__pfet_01v8 ad=0.3864 pd=2.93 as=0.196 ps=1.47 w=1.12 l=0.15
X349 a_7325_n1177.t0 sky130_fd_sc_hs__and2_1_3.X.t2 a_7238_n1177.t0 VGND.t14 sky130_fd_pr__nfet_01v8_lvt ad=0.1376 pd=1.14 as=0.1824 ps=1.85 w=0.64 l=0.15
X350 a_12413_n850.t0 a_11879_n1239.t3 a_12306_n810.t0 VGND.t9 sky130_fd_pr__nfet_01v8_lvt ad=0.07875 pd=0.865 as=0.15563 ps=1.215 w=0.42 l=0.15
X351 VGND.t117 a_8925_n51.t4 a_8943_n408.t1 VGND.t116 sky130_fd_pr__nfet_01v8_lvt ad=0.1648 pd=1.245 as=0.0441 ps=0.63 w=0.42 l=0.15
X352 a_14975_n889.t3 a_13991_n1239.t4 a_14677_n855.t3 VPWR.t198 sky130_fd_pr__pfet_01v8 ad=0.1428 pd=1.225 as=0.2331 ps=1.395 w=0.84 l=0.15
X353 VPWR.t34 sky130_fd_sc_hs__xor2_1_1.B.t5 a_3502_n1177.t1 VPWR.t33 sky130_fd_pr__pfet_01v8 ad=0.1988 pd=1.505 as=0.147 ps=1.19 w=0.84 l=0.15
X354 VGND.t165 sky130_fd_sc_hs__nor2b_1_7.B_N.t3 a_11399_n1201.t1 VGND.t164 sky130_fd_pr__nfet_01v8_lvt ad=0.15358 pd=1.2 as=0.2805 ps=2.12 w=0.55 l=0.15
X355 a_12997_n46.t3 a_12463_n435.t3 a_12890_n6.t2 VGND.t313 sky130_fd_pr__nfet_01v8_lvt ad=0.07875 pd=0.865 as=0.15563 ps=1.215 w=0.42 l=0.15
X356 a_8666_n6.t0 sky130_fd_sc_hs__nor2b_1_3.Y.t3 VGND.t12 VGND.t11 sky130_fd_pr__nfet_01v8_lvt ad=0.15563 pd=1.215 as=0.23015 ps=2.1 w=0.42 l=0.15
X357 VPWR.t60 a_14975_n889.t5 a_15174_n999.t0 VPWR.t59 sky130_fd_pr__pfet_01v8 ad=0.1862 pd=1.475 as=0.2478 ps=2.27 w=0.84 l=0.15
X358 a_12234_n141.t1 rst.t7 VPWR.t258 VPWR.t257 sky130_fd_pr__pfet_01v8 ad=0.1512 pd=1.39 as=0.2345 ps=1.58 w=1.12 l=0.15
X359 a_14754_n141.t1 a_14575_n435.t7 VPWR.t330 VPWR.t329 sky130_fd_pr__pfet_01v8 ad=0.3304 pd=2.83 as=0.168 ps=1.42 w=1.12 l=0.15
X360 VGND.t103 sky130_fd_sc_hs__and2_1_6.B.t2 a_9809_n1177.t0 VGND.t102 sky130_fd_pr__nfet_01v8_lvt ad=0.15535 pd=1.17 as=0.1376 ps=1.14 w=0.64 l=0.15
X361 a_2437_n46.t3 a_1903_n435.t3 a_2330_n6.t2 VGND.t236 sky130_fd_pr__nfet_01v8_lvt ad=0.07875 pd=0.865 as=0.15563 ps=1.215 w=0.42 l=0.15
X362 VGND.t203 sky130_fd_sc_hs__and2_1_7.X.t2 a_13511_n1201.t1 VGND.t202 sky130_fd_pr__nfet_01v8_lvt ad=0.15358 pd=1.2 as=0.2805 ps=2.12 w=0.55 l=0.15
X363 a_1674_n141.t0 rst.t17 VPWR.t256 VPWR.t255 sky130_fd_pr__pfet_01v8 ad=0.1512 pd=1.39 as=0.2345 ps=1.58 w=1.12 l=0.15
X364 a_2082_n141.t0 a_1903_n435.t5 VGND.t115 VGND.t114 sky130_fd_pr__nfet_01v8_lvt ad=0.2553 pd=2.17 as=0.1739 ps=1.21 w=0.74 l=0.15
X365 VPWR.t36 sky130_fd_sc_hs__and2_1_7.B.t5 a_10950_n1177.t2 VPWR.t35 sky130_fd_pr__pfet_01v8 ad=0.1988 pd=1.505 as=0.147 ps=1.19 w=0.84 l=0.15
X366 a_15279_n408.t1 a_14754_n141.t3 a_15109_n46.t3 VGND.t339 sky130_fd_pr__nfet_01v8_lvt ad=0.0441 pd=0.63 as=0.07875 ps=0.865 w=0.42 l=0.15
X367 VGND.t149 sky130_fd_sc_hs__and2_1_3.B.t2 a_6077_n1177.t0 VGND.t148 sky130_fd_pr__nfet_01v8_lvt ad=0.15535 pd=1.17 as=0.1376 ps=1.14 w=0.64 l=0.15
X368 VPWR.t300 sky130_fd_sc_hs__and2_1_4.X.t6 a_8015_n945.t1 VPWR.t299 sky130_fd_pr__pfet_01v8 ad=0.2352 pd=1.54 as=0.3752 ps=2.91 w=1.12 l=0.15
X369 a_8773_n46.t2 a_8418_n141.t5 a_8666_n6.t2 VPWR.t206 sky130_fd_pr__pfet_01v8 ad=0.09835 pd=1.005 as=0.09835 ps=1.005 w=0.42 l=0.15
X370 a_8773_n46.t3 a_8239_n435.t3 a_8666_n6.t3 VGND.t312 sky130_fd_pr__nfet_01v8_lvt ad=0.07875 pd=0.865 as=0.15563 ps=1.215 w=0.42 l=0.15
X371 sky130_fd_sc_hs__and2_1_3.X.t1 a_5990_n1177.t3 VGND.t160 VGND.t159 sky130_fd_pr__nfet_01v8_lvt ad=0.2109 pd=2.05 as=0.15535 ps=1.17 w=0.74 l=0.15
X372 VGND.t145 a_15758_n195.t3 a_15716_n385.t1 VGND.t144 sky130_fd_pr__nfet_01v8_lvt ad=0.1197 pd=1.41 as=0.05565 ps=0.685 w=0.42 l=0.15
X373 a_4719_n408.t0 a_4194_n141.t3 a_4549_n46.t2 VGND.t37 sky130_fd_pr__nfet_01v8_lvt ad=0.0441 pd=0.63 as=0.07875 ps=0.865 w=0.42 l=0.15
X374 a_12058_n945.t1 a_11879_n1239.t5 VGND.t187 VGND.t186 sky130_fd_pr__nfet_01v8_lvt ad=0.2553 pd=2.17 as=0.1739 ps=1.21 w=0.74 l=0.15
X375 VGND.t230 sky130_fd_sc_hs__and2_1_3.B.t4 a_5362_n1188.t1 VGND.t229 sky130_fd_pr__nfet_01v8_lvt ad=0.12607 pd=1.1 as=0.17738 ps=1.195 w=0.55 l=0.15
X376 VGND.t208 a_9871_n397.t2 sky130_fd_sc_hs__nor2b_1_4.Y.t0 VGND.t207 sky130_fd_pr__nfet_01v8_lvt ad=0.2627 pd=2.19 as=0.13135 ps=1.095 w=0.74 l=0.15
X377 sky130_fd_sc_hs__and2_1_2.X.t0 a_4746_n1177.t4 VPWR.t115 VPWR.t114 sky130_fd_pr__pfet_01v8 ad=0.3304 pd=2.83 as=0.1988 ps=1.505 w=1.12 l=0.15
X378 VPWR.t238 clk.t13 a_6127_n435.t0 VPWR.t237 sky130_fd_pr__pfet_01v8 ad=0.168 pd=1.42 as=0.3304 ps=2.83 w=1.12 l=0.15
X379 a_4080_n921.t0 sky130_fd_sc_hs__and2_1_1.X.t7 VPWR.t40 VPWR.t39 sky130_fd_pr__pfet_01v8 ad=0.135 pd=1.27 as=0.295 ps=2.59 w=1 l=0.15
X380 sky130_fd_sc_hs__and2_1_0.X.t0 a_2254_n1177.t4 VPWR.t11 VPWR.t10 sky130_fd_pr__pfet_01v8 ad=0.3304 pd=2.83 as=0.1988 ps=1.505 w=1.12 l=0.15
X381 VPWR.t196 a_2887_n85.t5 a_3086_n195.t0 VPWR.t195 sky130_fd_pr__pfet_01v8 ad=0.1862 pd=1.475 as=0.2478 ps=2.27 w=0.84 l=0.15
X382 sky130_fd_sc_hs__dfxtp_1_5.D.t1 rst.t6 VGND.t281 VGND.t280 sky130_fd_pr__nfet_01v8_lvt ad=0.13135 pd=1.095 as=0.15358 ps=1.2 w=0.74 l=0.15
X383 a_14170_n945.t0 a_13991_n1239.t5 VGND.t225 VGND.t224 sky130_fd_pr__nfet_01v8_lvt ad=0.2553 pd=2.17 as=0.1739 ps=1.21 w=0.74 l=0.15
X384 a_8571_n1177.t0 sky130_fd_sc_hs__and2_1_4.X.t2 a_8484_n1177.t0 VGND.t41 sky130_fd_pr__nfet_01v8_lvt ad=0.1376 pd=1.14 as=0.1824 ps=1.85 w=0.64 l=0.15
X385 sky130_fd_sc_hs__xor2_1_1.B.t0 a_5198_n195.t4 VPWR.t7 VPWR.t6 sky130_fd_pr__pfet_01v8 ad=0.3304 pd=2.83 as=0.1862 ps=1.475 w=1.12 l=0.15
X386 a_2887_n85.t1 a_1903_n435.t4 a_2589_n51.t1 VPWR.t143 sky130_fd_pr__pfet_01v8 ad=0.1428 pd=1.225 as=0.2331 ps=1.395 w=0.84 l=0.15
X387 VGND.t242 sky130_fd_sc_hs__and2_1_7.B.t2 a_11037_n1177.t1 VGND.t241 sky130_fd_pr__nfet_01v8_lvt ad=0.15535 pd=1.17 as=0.1376 ps=1.14 w=0.64 l=0.15
X388 sky130_fd_sc_hs__dfxtp_1_8.D.t1 rst.t16 VGND.t285 VGND.t284 sky130_fd_pr__nfet_01v8_lvt ad=0.13135 pd=1.095 as=0.15358 ps=1.2 w=0.74 l=0.15
X389 a_13104_n6.t0 a_12463_n435.t6 a_12997_n46.t1 VPWR.t185 sky130_fd_pr__pfet_01v8 ad=0.0504 pd=0.66 as=0.09835 ps=1.005 w=0.42 l=0.15
X390 VPWR.t141 sky130_fd_sc_hs__and2_1_6.B.t5 a_9722_n1177.t1 VPWR.t140 sky130_fd_pr__pfet_01v8 ad=0.1988 pd=1.505 as=0.147 ps=1.19 w=0.84 l=0.15
X391 VGND.t262 clk.t0 a_13991_n1239.t1 VGND.t261 sky130_fd_pr__nfet_01v8_lvt ad=0.1739 pd=1.21 as=0.2109 ps=2.05 w=0.74 l=0.15
X392 sky130_fd_sc_hs__and2_1_7.X.t1 a_10950_n1177.t3 VGND.t97 VGND.t96 sky130_fd_pr__nfet_01v8_lvt ad=0.2109 pd=2.05 as=0.15535 ps=1.17 w=0.74 l=0.15
X393 a_2872_n1188.t0 sky130_fd_sc_hs__xor2_1_1.B.t7 a_2836_n921.t0 VPWR.t142 sky130_fd_pr__pfet_01v8 ad=0.295 pd=2.59 as=0.135 ps=1.27 w=1 l=0.15
X394 VPWR.t234 en.t4 a_1787_n945.t2 VPWR.t233 sky130_fd_pr__pfet_01v8 ad=0.2352 pd=1.54 as=0.3752 ps=2.91 w=1.12 l=0.15
X395 VPWR.t96 a_9223_n85.t5 a_9422_n195.t0 VPWR.t95 sky130_fd_pr__pfet_01v8 ad=0.1862 pd=1.475 as=0.2478 ps=2.27 w=0.84 l=0.15
X396 a_9100_n1188.t1 sky130_fd_sc_hs__and2_1_5.X.t4 VGND.t101 VGND.t100 sky130_fd_pr__nfet_01v8_lvt ad=0.17738 pd=1.195 as=0.33275 ps=2.31 w=0.55 l=0.15
X397 a_6306_n141.t1 a_6127_n435.t7 VPWR.t306 VPWR.t305 sky130_fd_pr__pfet_01v8 ad=0.3304 pd=2.83 as=0.168 ps=1.42 w=1.12 l=0.15
R0 overflow.t0 overflow.n1 279.738
R1 overflow.n2 overflow.t0 279.738
R2 overflow.n0 overflow.t1 266.137
R3 overflow.n1 overflow.n0 29.0015
R4 overflow overflow.n2 11.5561
R5 overflow.n0 overflow 9.62211
R6 overflow overflow.n1 4.44494
R7 overflow.n2 overflow 1.6005
R8 en.t2 en.t1 803.333
R9 en.t1 en.t4 484.947
R10 en.t0 en.t3 446.654
R11 en.n3 en.t5 260.281
R12 en.n0 en.t0 226.732
R13 en.n3 en.t2 173.228
R14 en.n4 en.n3 97.4339
R15 en.n4 en.n2 14.6999
R16 en.n2 en.n1 11.9215
R17 en en.n4 8.93268
R18 en.n1 en.n0 6.42531
R19 en.n0 en 5.14939
R20 en.n1 en 2.93062
R21 en.n2 en 1.04829
R22 clk.n24 clk.t17 259.132
R23 clk.n21 clk.t15 259.132
R24 clk.n18 clk.t13 259.132
R25 clk.n15 clk.t11 259.132
R26 clk.n12 clk.t9 259.132
R27 clk.n6 clk.t3 259.132
R28 clk.n8 clk.t7 259.132
R29 clk.n0 clk.t1 259.132
R30 clk.n2 clk.t5 259.132
R31 clk.n24 clk.t16 198.882
R32 clk.n21 clk.t14 198.882
R33 clk.n18 clk.t12 198.882
R34 clk.n15 clk.t10 198.882
R35 clk.n12 clk.t8 198.882
R36 clk.n6 clk.t2 198.882
R37 clk.n8 clk.t6 198.882
R38 clk.n0 clk.t0 198.882
R39 clk.n2 clk.t4 198.882
R40 clk.n9 clk.n8 154.4
R41 clk.n1 clk.n0 153.201
R42 clk.n13 clk.n12 152.934
R43 clk.n3 clk.n2 152.667
R44 clk.n16 clk.n15 152.4
R45 clk.n19 clk.n18 152.133
R46 clk.n25 clk.n24 152
R47 clk.n22 clk.n21 152
R48 clk.n7 clk.n6 152
R49 clk.n25 clk.n23 26.5671
R50 clk.n23 clk.n22 20.0069
R51 clk.n20 clk.n19 19.9149
R52 clk.n17 clk.n16 19.8369
R53 clk.n14 clk.n13 19.8108
R54 clk.n10 clk.n7 18.1759
R55 clk.n4 clk.n1 17.5679
R56 clk.n10 clk.n9 13.8151
R57 clk.n4 clk.n3 13.8005
R58 clk.n11 clk.n5 7.66849
R59 clk.n17 clk.n14 7.65378
R60 clk.n14 clk.n11 7.60966
R61 clk.n20 clk.n17 6.85568
R62 clk.n5 clk.n4 6.34992
R63 clk.n11 clk.n10 6.25582
R64 clk.n23 clk.n20 5.93871
R65 clk clk.n25 4.93383
R66 clk.n22 clk 4.93383
R67 clk.n7 clk 4.93383
R68 clk.n19 clk 4.8005
R69 clk.n16 clk 4.53383
R70 clk.n3 clk 4.26717
R71 clk.n13 clk 4.0005
R72 clk.n1 clk 3.73383
R73 clk.n9 clk 2.53383
R74 clk.n5 clk 0.166584
R75 rst.n0 rst.t1 283.113
R76 rst.n1 rst.t5 283.113
R77 rst.n18 rst.t7 283.113
R78 rst.n20 rst.t3 283.113
R79 rst.n3 rst.t9 283.113
R80 rst.n14 rst.t11 283.113
R81 rst.n11 rst.t13 283.113
R82 rst.n8 rst.t15 283.113
R83 rst.n5 rst.t17 283.113
R84 rst.n0 rst.t0 175.736
R85 rst.n1 rst.t4 175.736
R86 rst.n18 rst.t6 175.736
R87 rst.n20 rst.t2 175.736
R88 rst.n3 rst.t8 175.736
R89 rst.n14 rst.t10 175.736
R90 rst.n11 rst.t12 175.736
R91 rst.n8 rst.t14 175.736
R92 rst.n5 rst.t16 175.736
R93 rst.n6 rst.n5 154.327
R94 rst.n25 rst.n0 153.358
R95 rst.n19 rst.n18 152.776
R96 rst.n2 rst.n1 152.583
R97 rst.n9 rst.n8 152.388
R98 rst.n21 rst.n20 152
R99 rst.n4 rst.n3 152
R100 rst.n15 rst.n14 152
R101 rst.n12 rst.n11 152
R102 rst.n22 rst.n21 27.8305
R103 rst.n7 rst.n6 20.3108
R104 rst.n10 rst.n9 20.2684
R105 rst.n16 rst.n15 19.9724
R106 rst.n17 rst.n4 19.9657
R107 rst.n13 rst.n12 19.6227
R108 rst.n25 rst.n24 18.1433
R109 rst.n22 rst.n19 14.2278
R110 rst.n24 rst.n2 14.049
R111 rst.n24 rst.n23 13.2844
R112 rst.n10 rst.n7 6.8919
R113 rst.n21 rst 6.78838
R114 rst.n4 rst 6.78838
R115 rst.n15 rst 6.78838
R116 rst.n12 rst 6.78838
R117 rst.n23 rst.n17 6.40591
R118 rst.n9 rst 6.4005
R119 rst.n2 rst 6.20656
R120 rst.n19 rst 6.01262
R121 rst.n13 rst.n10 5.64394
R122 rst.n17 rst.n16 5.52834
R123 rst rst.n25 5.4308
R124 rst.n16 rst.n13 5.39566
R125 rst.n23 rst.n22 5.38671
R126 rst.n6 rst 4.46111
R127 rst.n7 rst 0.183366
R128 VPWR.n135 VPWR.t25 840.035
R129 VPWR.n80 VPWR.t89 840.035
R130 VPWR.n65 VPWR.t120 840.035
R131 VPWR.n50 VPWR.t146 840.035
R132 VPWR.n35 VPWR.t86 840.035
R133 VPWR.n20 VPWR.t200 840.035
R134 VPWR.n704 VPWR.t98 840.035
R135 VPWR.n163 VPWR.t296 840.035
R136 VPWR.n410 VPWR.t103 840.035
R137 VPWR.t17 VPWR.n117 729.346
R138 VPWR.n113 VPWR.t187 677.855
R139 VPWR.n683 VPWR.t134 677.855
R140 VPWR.n647 VPWR.t136 677.855
R141 VPWR.n611 VPWR.t223 677.855
R142 VPWR.n575 VPWR.t210 677.855
R143 VPWR.n539 VPWR.t285 677.855
R144 VPWR.n503 VPWR.t58 677.855
R145 VPWR.n172 VPWR.t72 677.855
R146 VPWR.n461 VPWR.t290 677.855
R147 VPWR.n712 VPWR.n711 659.098
R148 VPWR.n91 VPWR.n90 659.098
R149 VPWR.n76 VPWR.n75 659.098
R150 VPWR.n61 VPWR.n60 659.098
R151 VPWR.n46 VPWR.n45 659.098
R152 VPWR.n31 VPWR.n30 659.098
R153 VPWR.n17 VPWR.n16 659.098
R154 VPWR.n159 VPWR.n158 659.098
R155 VPWR.n418 VPWR.n417 659.098
R156 VPWR.t303 VPWR.t24 633.333
R157 VPWR.t37 VPWR.t88 633.333
R158 VPWR.t305 VPWR.t119 633.333
R159 VPWR.t27 VPWR.t145 633.333
R160 VPWR.t293 VPWR.t85 633.333
R161 VPWR.t51 VPWR.t199 633.333
R162 VPWR.t329 VPWR.t97 633.333
R163 VPWR.t69 VPWR.t102 633.333
R164 VPWR.t325 VPWR.t295 633.333
R165 VPWR.n254 VPWR.n241 599.982
R166 VPWR.n276 VPWR.n232 599.982
R167 VPWR.n297 VPWR.n224 599.982
R168 VPWR.n319 VPWR.n215 599.982
R169 VPWR.n340 VPWR.n207 599.982
R170 VPWR.n362 VPWR.n198 599.982
R171 VPWR.n383 VPWR.n190 599.982
R172 VPWR.n478 VPWR.n477 599.982
R173 VPWR.t150 VPWR.n466 592.348
R174 VPWR.t159 VPWR.t233 536.29
R175 VPWR.t142 VPWR.t316 536.29
R176 VPWR.t67 VPWR.t331 536.29
R177 VPWR.t309 VPWR.t274 536.29
R178 VPWR.t193 VPWR.t276 536.29
R179 VPWR.t156 VPWR.t299 536.29
R180 VPWR.t111 VPWR.t105 536.29
R181 VPWR.t15 VPWR.t310 536.29
R182 VPWR.t57 VPWR.t195 515.861
R183 VPWR.t284 VPWR.t322 515.861
R184 VPWR.t209 VPWR.t170 515.861
R185 VPWR.t222 VPWR.t95 515.861
R186 VPWR.t135 VPWR.t224 515.861
R187 VPWR.t133 VPWR.t177 515.861
R188 VPWR.t186 VPWR.t174 515.861
R189 VPWR.t71 VPWR.t333 515.861
R190 VPWR.t289 VPWR.t59 515.861
R191 VPWR.n238 VPWR.t2 402.512
R192 VPWR.n282 VPWR.t315 402.512
R193 VPWR.n221 VPWR.t166 402.512
R194 VPWR.n325 VPWR.t123 402.512
R195 VPWR.n204 VPWR.t80 402.512
R196 VPWR.n368 VPWR.t50 402.512
R197 VPWR.n187 VPWR.t30 402.512
R198 VPWR.n147 VPWR.t232 402.512
R199 VPWR VPWR.t231 380.512
R200 VPWR VPWR.t1 380.512
R201 VPWR VPWR.t314 380.512
R202 VPWR VPWR.t165 380.512
R203 VPWR VPWR.t122 380.512
R204 VPWR VPWR.t79 380.512
R205 VPWR VPWR.t49 380.512
R206 VPWR VPWR.t29 380.512
R207 VPWR VPWR.t229 365.188
R208 VPWR VPWR.t152 365.188
R209 VPWR VPWR.t39 365.188
R210 VPWR VPWR.t83 365.188
R211 VPWR VPWR.t8 365.188
R212 VPWR VPWR.t108 365.188
R213 VPWR VPWR.t191 365.188
R214 VPWR VPWR.t12 365.188
R215 VPWR VPWR.t312 360.082
R216 VPWR.t160 VPWR.t143 360.082
R217 VPWR VPWR.t116 360.082
R218 VPWR.t61 VPWR.t121 360.082
R219 VPWR VPWR.t220 360.082
R220 VPWR.t319 VPWR.t99 360.082
R221 VPWR VPWR.t271 360.082
R222 VPWR.t100 VPWR.t179 360.082
R223 VPWR VPWR.t65 360.082
R224 VPWR.t301 VPWR.t68 360.082
R225 VPWR VPWR.t45 360.082
R226 VPWR.t213 VPWR.t16 360.082
R227 VPWR VPWR.t227 360.082
R228 VPWR.t297 VPWR.t26 360.082
R229 VPWR VPWR.t77 360.082
R230 VPWR.t211 VPWR.t180 360.082
R231 VPWR VPWR.t131 360.082
R232 VPWR.t154 VPWR.t198 360.082
R233 VPWR.t321 VPWR 339.651
R234 VPWR.t128 VPWR 339.651
R235 VPWR.t184 VPWR 339.651
R236 VPWR.t87 VPWR 339.651
R237 VPWR.t281 VPWR 339.651
R238 VPWR.t90 VPWR 339.651
R239 VPWR.t324 VPWR 339.651
R240 VPWR.t226 VPWR 339.651
R241 VPWR.t328 VPWR 339.651
R242 VPWR.n468 VPWR 334.418
R243 VPWR.n6 VPWR.n5 331.5
R244 VPWR.n665 VPWR.n21 331.5
R245 VPWR.n629 VPWR.n36 331.5
R246 VPWR.n593 VPWR.n51 331.5
R247 VPWR.n557 VPWR.n66 331.5
R248 VPWR.n521 VPWR.n81 331.5
R249 VPWR.n98 VPWR.n97 331.5
R250 VPWR.n179 VPWR.n178 331.5
R251 VPWR.n443 VPWR.n164 331.5
R252 VPWR.n118 VPWR 329.31
R253 VPWR.n115 VPWR.n103 327.166
R254 VPWR.n686 VPWR.n685 327.166
R255 VPWR.n26 VPWR.n25 327.166
R256 VPWR.n41 VPWR.n40 327.166
R257 VPWR.n56 VPWR.n55 327.166
R258 VPWR.n71 VPWR.n70 327.166
R259 VPWR.n86 VPWR.n85 327.166
R260 VPWR.n430 VPWR.n171 327.166
R261 VPWR.n463 VPWR.n154 327.166
R262 VPWR.t169 VPWR.t57 319.221
R263 VPWR.t162 VPWR.t284 319.221
R264 VPWR.t286 VPWR.t209 319.221
R265 VPWR.t176 VPWR.t222 319.221
R266 VPWR.t318 VPWR.t135 319.221
R267 VPWR.t118 VPWR.t133 319.221
R268 VPWR.t113 VPWR.t186 319.221
R269 VPWR.t5 VPWR.t71 319.221
R270 VPWR.t197 VPWR.t289 319.221
R271 VPWR.n489 VPWR.n488 316.87
R272 VPWR.n264 VPWR.n237 316.87
R273 VPWR.n228 VPWR.n227 316.87
R274 VPWR.n307 VPWR.n220 316.87
R275 VPWR.n211 VPWR.n210 316.87
R276 VPWR.n350 VPWR.n203 316.87
R277 VPWR.n194 VPWR.n193 316.87
R278 VPWR.n393 VPWR.n186 316.87
R279 VPWR.t291 VPWR.t160 316.668
R280 VPWR.t157 VPWR.t61 316.668
R281 VPWR.t307 VPWR.t319 316.668
R282 VPWR.t148 VPWR.t100 316.668
R283 VPWR.t81 VPWR.t301 316.668
R284 VPWR.t216 VPWR.t213 316.668
R285 VPWR.t287 VPWR.t297 316.668
R286 VPWR.t10 VPWR 316.668
R287 VPWR.t91 VPWR 316.668
R288 VPWR.t163 VPWR 316.668
R289 VPWR.t129 VPWR.t211 316.668
R290 VPWR.t335 VPWR.t154 316.668
R291 VPWR.t312 VPWR.t255 311.56
R292 VPWR.t116 VPWR.t253 311.56
R293 VPWR.t220 VPWR.t263 311.56
R294 VPWR.t271 VPWR.t267 311.56
R295 VPWR.t65 VPWR.t261 311.56
R296 VPWR.t45 VPWR.t257 311.56
R297 VPWR.t227 VPWR.t269 311.56
R298 VPWR.t114 VPWR 311.56
R299 VPWR.t22 VPWR 311.56
R300 VPWR.t93 VPWR 311.56
R301 VPWR.t3 VPWR 311.56
R302 VPWR.t77 VPWR.t265 311.56
R303 VPWR.t131 VPWR.t259 311.56
R304 VPWR.t19 VPWR 306.452
R305 VPWR.t110 VPWR 298.791
R306 VPWR.t41 VPWR 298.791
R307 VPWR.t0 VPWR 298.791
R308 VPWR.t327 VPWR 298.791
R309 VPWR.t194 VPWR 293.683
R310 VPWR.t73 VPWR 293.683
R311 VPWR.t233 VPWR.t137 291.13
R312 VPWR.t316 VPWR.t278 291.13
R313 VPWR.t331 VPWR.t124 291.13
R314 VPWR.t274 VPWR.t189 291.13
R315 VPWR.t276 VPWR.t31 291.13
R316 VPWR.t299 VPWR.t63 291.13
R317 VPWR.t105 VPWR.t126 291.13
R318 VPWR.t310 VPWR.t53 291.13
R319 VPWR.t205 VPWR 278.361
R320 VPWR.t24 VPWR.t42 273.253
R321 VPWR.t42 VPWR.t144 273.253
R322 VPWR.t143 VPWR.t169 273.253
R323 VPWR.t88 VPWR.t147 273.253
R324 VPWR.t147 VPWR.t14 273.253
R325 VPWR.t121 VPWR.t162 273.253
R326 VPWR.t119 VPWR.t181 273.253
R327 VPWR.t181 VPWR.t273 273.253
R328 VPWR.t99 VPWR.t286 273.253
R329 VPWR.t145 VPWR.t206 273.253
R330 VPWR.t206 VPWR.t204 273.253
R331 VPWR.t179 VPWR.t176 273.253
R332 VPWR.t85 VPWR.t104 273.253
R333 VPWR.t104 VPWR.t280 273.253
R334 VPWR.t68 VPWR.t318 273.253
R335 VPWR.t199 VPWR.t201 273.253
R336 VPWR.t201 VPWR.t185 273.253
R337 VPWR.t16 VPWR.t118 273.253
R338 VPWR.t97 VPWR.t107 273.253
R339 VPWR.t107 VPWR.t215 273.253
R340 VPWR.t26 VPWR.t113 273.253
R341 VPWR.t218 VPWR.t10 273.253
R342 VPWR.t33 VPWR.t19 273.253
R343 VPWR.t207 VPWR.t114 273.253
R344 VPWR.t172 VPWR.t91 273.253
R345 VPWR.t47 VPWR.t22 273.253
R346 VPWR.t182 VPWR.t93 273.253
R347 VPWR.t140 VPWR.t163 273.253
R348 VPWR.t35 VPWR.t3 273.253
R349 VPWR.t102 VPWR.t21 273.253
R350 VPWR.t21 VPWR.t112 273.253
R351 VPWR.t180 VPWR.t5 273.253
R352 VPWR.t295 VPWR.t74 273.253
R353 VPWR.t74 VPWR.t188 273.253
R354 VPWR.t198 VPWR.t197 273.253
R355 VPWR VPWR.t239 257.93
R356 VPWR.t195 VPWR.t167 257.93
R357 VPWR.t167 VPWR 257.93
R358 VPWR VPWR.t241 257.93
R359 VPWR.t322 VPWR.t6 257.93
R360 VPWR.t6 VPWR 257.93
R361 VPWR VPWR.t237 257.93
R362 VPWR.t170 VPWR.t202 257.93
R363 VPWR.t202 VPWR 257.93
R364 VPWR VPWR.t243 257.93
R365 VPWR.t95 VPWR.t282 257.93
R366 VPWR.t282 VPWR 257.93
R367 VPWR VPWR.t245 257.93
R368 VPWR.t224 VPWR.t43 257.93
R369 VPWR.t43 VPWR 257.93
R370 VPWR VPWR.t235 257.93
R371 VPWR.t177 VPWR.t55 257.93
R372 VPWR.t55 VPWR 257.93
R373 VPWR VPWR.t249 257.93
R374 VPWR.t174 VPWR.t17 257.93
R375 VPWR VPWR.t247 257.93
R376 VPWR.t333 VPWR.t75 257.93
R377 VPWR.t75 VPWR 257.93
R378 VPWR VPWR.t251 257.93
R379 VPWR.t59 VPWR.t150 257.93
R380 VPWR.t137 VPWR.t194 255.376
R381 VPWR.t231 VPWR.t218 255.376
R382 VPWR.t278 VPWR.t110 255.376
R383 VPWR.t1 VPWR.t33 255.376
R384 VPWR.t124 VPWR.t41 255.376
R385 VPWR.t314 VPWR.t207 255.376
R386 VPWR.t189 VPWR.t73 255.376
R387 VPWR.t165 VPWR.t172 255.376
R388 VPWR.t31 VPWR.t0 255.376
R389 VPWR.t122 VPWR.t47 255.376
R390 VPWR.t63 VPWR.t327 255.376
R391 VPWR.t79 VPWR.t182 255.376
R392 VPWR.t126 VPWR.t205 255.376
R393 VPWR.t49 VPWR.t140 255.376
R394 VPWR.t53 VPWR.t139 255.376
R395 VPWR.t29 VPWR.t35 255.376
R396 VPWR.n247 VPWR.t153 252.013
R397 VPWR.n269 VPWR.t40 252.013
R398 VPWR.n290 VPWR.t84 252.013
R399 VPWR.n312 VPWR.t9 252.013
R400 VPWR.n333 VPWR.t109 252.013
R401 VPWR.n355 VPWR.t192 252.013
R402 VPWR.n376 VPWR.t13 252.013
R403 VPWR.n470 VPWR.t230 252.013
R404 VPWR.t139 VPWR 247.715
R405 VPWR.n693 VPWR.n692 232.201
R406 VPWR.n658 VPWR.n657 232.201
R407 VPWR.n622 VPWR.n621 232.201
R408 VPWR.n586 VPWR.n585 232.201
R409 VPWR.n550 VPWR.n549 232.201
R410 VPWR.n514 VPWR.n513 232.201
R411 VPWR.n124 VPWR.n123 232.201
R412 VPWR.n399 VPWR.n183 232.201
R413 VPWR.n436 VPWR.n168 232.201
R414 VPWR.t239 VPWR.t303 229.839
R415 VPWR.t241 VPWR.t37 229.839
R416 VPWR.t237 VPWR.t305 229.839
R417 VPWR.t243 VPWR.t27 229.839
R418 VPWR.t245 VPWR.t293 229.839
R419 VPWR.t235 VPWR.t51 229.839
R420 VPWR.t249 VPWR.t329 229.839
R421 VPWR.t247 VPWR.t69 229.839
R422 VPWR.t251 VPWR.t325 229.839
R423 VPWR.t255 VPWR.t321 214.517
R424 VPWR.t253 VPWR.t128 214.517
R425 VPWR.t263 VPWR.t184 214.517
R426 VPWR.t267 VPWR.t87 214.517
R427 VPWR.t261 VPWR.t281 214.517
R428 VPWR.t257 VPWR.t90 214.517
R429 VPWR.t269 VPWR.t324 214.517
R430 VPWR.t229 VPWR.t159 214.517
R431 VPWR.t152 VPWR.t142 214.517
R432 VPWR.t39 VPWR.t67 214.517
R433 VPWR.t83 VPWR.t309 214.517
R434 VPWR.t8 VPWR.t193 214.517
R435 VPWR.t108 VPWR.t156 214.517
R436 VPWR.t191 VPWR.t111 214.517
R437 VPWR.t12 VPWR.t15 214.517
R438 VPWR.t265 VPWR.t226 214.517
R439 VPWR.t259 VPWR.t328 214.517
R440 VPWR.t144 VPWR.t291 199.195
R441 VPWR.t14 VPWR.t157 199.195
R442 VPWR.t273 VPWR.t307 199.195
R443 VPWR.t204 VPWR.t148 199.195
R444 VPWR.t280 VPWR.t81 199.195
R445 VPWR.t185 VPWR.t216 199.195
R446 VPWR.t215 VPWR.t287 199.195
R447 VPWR.t112 VPWR.t129 199.195
R448 VPWR.t188 VPWR.t335 199.195
R449 VPWR.n711 VPWR.t288 131.333
R450 VPWR.n90 VPWR.t292 131.333
R451 VPWR.n75 VPWR.t158 131.333
R452 VPWR.n60 VPWR.t308 131.333
R453 VPWR.n45 VPWR.t149 131.333
R454 VPWR.n30 VPWR.t82 131.333
R455 VPWR.n16 VPWR.t217 131.333
R456 VPWR.n158 VPWR.t336 131.333
R457 VPWR.n417 VPWR.t130 131.333
R458 VPWR.n692 VPWR.t228 72.7029
R459 VPWR.n657 VPWR.t46 72.7029
R460 VPWR.n621 VPWR.t66 72.7029
R461 VPWR.n585 VPWR.t272 72.7029
R462 VPWR.n549 VPWR.t221 72.7029
R463 VPWR.n513 VPWR.t117 72.7029
R464 VPWR.n123 VPWR.t313 72.7029
R465 VPWR.n183 VPWR.t78 72.7029
R466 VPWR.n168 VPWR.t132 72.7029
R467 VPWR.n488 VPWR.t219 55.1136
R468 VPWR.n237 VPWR.t34 55.1136
R469 VPWR.n227 VPWR.t208 55.1136
R470 VPWR.n220 VPWR.t173 55.1136
R471 VPWR.n210 VPWR.t48 55.1136
R472 VPWR.n203 VPWR.t183 55.1136
R473 VPWR.n193 VPWR.t141 55.1136
R474 VPWR.n186 VPWR.t36 55.1136
R475 VPWR.n711 VPWR.t298 45.4599
R476 VPWR.n90 VPWR.t161 45.4599
R477 VPWR.n75 VPWR.t62 45.4599
R478 VPWR.n60 VPWR.t320 45.4599
R479 VPWR.n45 VPWR.t101 45.4599
R480 VPWR.n30 VPWR.t302 45.4599
R481 VPWR.n16 VPWR.t214 45.4599
R482 VPWR.n158 VPWR.t155 45.4599
R483 VPWR.n417 VPWR.t212 45.4599
R484 VPWR.n103 VPWR.t18 43.8979
R485 VPWR.n685 VPWR.t56 43.8979
R486 VPWR.n25 VPWR.t44 43.8979
R487 VPWR.n40 VPWR.t283 43.8979
R488 VPWR.n55 VPWR.t203 43.8979
R489 VPWR.n70 VPWR.t7 43.8979
R490 VPWR.n85 VPWR.t168 43.8979
R491 VPWR.n171 VPWR.t76 43.8979
R492 VPWR.n154 VPWR.t151 43.8979
R493 VPWR.n241 VPWR.t317 37.8175
R494 VPWR.n232 VPWR.t332 37.8175
R495 VPWR.n224 VPWR.t275 37.8175
R496 VPWR.n215 VPWR.t277 37.8175
R497 VPWR.n207 VPWR.t300 37.8175
R498 VPWR.n198 VPWR.t106 37.8175
R499 VPWR.n190 VPWR.t311 37.8175
R500 VPWR.n477 VPWR.t234 37.8175
R501 VPWR.n705 VPWR.n3 36.1417
R502 VPWR.n709 VPWR.n3 36.1417
R503 VPWR.n710 VPWR.n709 36.1417
R504 VPWR.n108 VPWR.n2 36.1417
R505 VPWR.n108 VPWR.n105 36.1417
R506 VPWR.n112 VPWR.n105 36.1417
R507 VPWR.n697 VPWR.n8 36.1417
R508 VPWR.n698 VPWR.n697 36.1417
R509 VPWR.n699 VPWR.n698 36.1417
R510 VPWR.n690 VPWR.n10 36.1417
R511 VPWR.n691 VPWR.n690 36.1417
R512 VPWR.n678 VPWR.n677 36.1417
R513 VPWR.n679 VPWR.n678 36.1417
R514 VPWR.n679 VPWR.n12 36.1417
R515 VPWR.n671 VPWR.n18 36.1417
R516 VPWR.n672 VPWR.n671 36.1417
R517 VPWR.n673 VPWR.n672 36.1417
R518 VPWR.n660 VPWR.n659 36.1417
R519 VPWR.n660 VPWR.n22 36.1417
R520 VPWR.n664 VPWR.n22 36.1417
R521 VPWR.n653 VPWR.n652 36.1417
R522 VPWR.n653 VPWR.n24 36.1417
R523 VPWR.n642 VPWR.n641 36.1417
R524 VPWR.n642 VPWR.n28 36.1417
R525 VPWR.n646 VPWR.n28 36.1417
R526 VPWR.n635 VPWR.n33 36.1417
R527 VPWR.n636 VPWR.n635 36.1417
R528 VPWR.n637 VPWR.n636 36.1417
R529 VPWR.n624 VPWR.n623 36.1417
R530 VPWR.n624 VPWR.n37 36.1417
R531 VPWR.n628 VPWR.n37 36.1417
R532 VPWR.n617 VPWR.n616 36.1417
R533 VPWR.n617 VPWR.n39 36.1417
R534 VPWR.n606 VPWR.n605 36.1417
R535 VPWR.n606 VPWR.n43 36.1417
R536 VPWR.n610 VPWR.n43 36.1417
R537 VPWR.n599 VPWR.n48 36.1417
R538 VPWR.n600 VPWR.n599 36.1417
R539 VPWR.n601 VPWR.n600 36.1417
R540 VPWR.n588 VPWR.n587 36.1417
R541 VPWR.n588 VPWR.n52 36.1417
R542 VPWR.n592 VPWR.n52 36.1417
R543 VPWR.n581 VPWR.n580 36.1417
R544 VPWR.n581 VPWR.n54 36.1417
R545 VPWR.n570 VPWR.n569 36.1417
R546 VPWR.n570 VPWR.n58 36.1417
R547 VPWR.n574 VPWR.n58 36.1417
R548 VPWR.n563 VPWR.n63 36.1417
R549 VPWR.n564 VPWR.n563 36.1417
R550 VPWR.n565 VPWR.n564 36.1417
R551 VPWR.n552 VPWR.n551 36.1417
R552 VPWR.n552 VPWR.n67 36.1417
R553 VPWR.n556 VPWR.n67 36.1417
R554 VPWR.n545 VPWR.n544 36.1417
R555 VPWR.n545 VPWR.n69 36.1417
R556 VPWR.n534 VPWR.n533 36.1417
R557 VPWR.n534 VPWR.n73 36.1417
R558 VPWR.n538 VPWR.n73 36.1417
R559 VPWR.n527 VPWR.n78 36.1417
R560 VPWR.n528 VPWR.n527 36.1417
R561 VPWR.n529 VPWR.n528 36.1417
R562 VPWR.n516 VPWR.n515 36.1417
R563 VPWR.n516 VPWR.n82 36.1417
R564 VPWR.n520 VPWR.n82 36.1417
R565 VPWR.n509 VPWR.n508 36.1417
R566 VPWR.n509 VPWR.n84 36.1417
R567 VPWR.n498 VPWR.n497 36.1417
R568 VPWR.n498 VPWR.n88 36.1417
R569 VPWR.n502 VPWR.n88 36.1417
R570 VPWR.n136 VPWR.n94 36.1417
R571 VPWR.n140 VPWR.n94 36.1417
R572 VPWR.n141 VPWR.n140 36.1417
R573 VPWR.n128 VPWR.n100 36.1417
R574 VPWR.n129 VPWR.n128 36.1417
R575 VPWR.n130 VPWR.n129 36.1417
R576 VPWR.n122 VPWR.n121 36.1417
R577 VPWR.n487 VPWR.n146 36.1417
R578 VPWR.n246 VPWR.n145 36.1417
R579 VPWR.n248 VPWR.n242 36.1417
R580 VPWR.n252 VPWR.n242 36.1417
R581 VPWR.n253 VPWR.n252 36.1417
R582 VPWR.n258 VPWR.n239 36.1417
R583 VPWR.n259 VPWR.n258 36.1417
R584 VPWR.n263 VPWR.n262 36.1417
R585 VPWR.n271 VPWR.n270 36.1417
R586 VPWR.n271 VPWR.n233 36.1417
R587 VPWR.n275 VPWR.n233 36.1417
R588 VPWR.n277 VPWR.n230 36.1417
R589 VPWR.n281 VPWR.n230 36.1417
R590 VPWR.n284 VPWR.n283 36.1417
R591 VPWR.n291 VPWR.n225 36.1417
R592 VPWR.n295 VPWR.n225 36.1417
R593 VPWR.n296 VPWR.n295 36.1417
R594 VPWR.n301 VPWR.n222 36.1417
R595 VPWR.n306 VPWR.n305 36.1417
R596 VPWR.n311 VPWR.n218 36.1417
R597 VPWR.n314 VPWR.n313 36.1417
R598 VPWR.n314 VPWR.n216 36.1417
R599 VPWR.n318 VPWR.n216 36.1417
R600 VPWR.n320 VPWR.n213 36.1417
R601 VPWR.n324 VPWR.n213 36.1417
R602 VPWR.n327 VPWR.n326 36.1417
R603 VPWR.n334 VPWR.n208 36.1417
R604 VPWR.n338 VPWR.n208 36.1417
R605 VPWR.n339 VPWR.n338 36.1417
R606 VPWR.n344 VPWR.n205 36.1417
R607 VPWR.n345 VPWR.n344 36.1417
R608 VPWR.n349 VPWR.n348 36.1417
R609 VPWR.n357 VPWR.n356 36.1417
R610 VPWR.n357 VPWR.n199 36.1417
R611 VPWR.n361 VPWR.n199 36.1417
R612 VPWR.n363 VPWR.n196 36.1417
R613 VPWR.n370 VPWR.n369 36.1417
R614 VPWR.n375 VPWR.n374 36.1417
R615 VPWR.n377 VPWR.n191 36.1417
R616 VPWR.n381 VPWR.n191 36.1417
R617 VPWR.n382 VPWR.n381 36.1417
R618 VPWR.n387 VPWR.n188 36.1417
R619 VPWR.n392 VPWR.n391 36.1417
R620 VPWR.n398 VPWR.n397 36.1417
R621 VPWR.n403 VPWR.n181 36.1417
R622 VPWR.n404 VPWR.n403 36.1417
R623 VPWR.n405 VPWR.n404 36.1417
R624 VPWR.n411 VPWR.n176 36.1417
R625 VPWR.n415 VPWR.n176 36.1417
R626 VPWR.n416 VPWR.n415 36.1417
R627 VPWR.n423 VPWR.n174 36.1417
R628 VPWR.n424 VPWR.n423 36.1417
R629 VPWR.n425 VPWR.n424 36.1417
R630 VPWR.n431 VPWR.n169 36.1417
R631 VPWR.n435 VPWR.n169 36.1417
R632 VPWR.n438 VPWR.n437 36.1417
R633 VPWR.n438 VPWR.n165 36.1417
R634 VPWR.n442 VPWR.n165 36.1417
R635 VPWR.n449 VPWR.n161 36.1417
R636 VPWR.n450 VPWR.n449 36.1417
R637 VPWR.n451 VPWR.n450 36.1417
R638 VPWR.n456 VPWR.n455 36.1417
R639 VPWR.n456 VPWR.n156 36.1417
R640 VPWR.n460 VPWR.n156 36.1417
R641 VPWR.n482 VPWR.n148 36.1417
R642 VPWR.n471 VPWR.n150 36.1417
R643 VPWR.n475 VPWR.n150 36.1417
R644 VPWR.n476 VPWR.n475 36.1417
R645 VPWR.n241 VPWR.t279 36.0585
R646 VPWR.n232 VPWR.t125 36.0585
R647 VPWR.n224 VPWR.t190 36.0585
R648 VPWR.n215 VPWR.t32 36.0585
R649 VPWR.n207 VPWR.t64 36.0585
R650 VPWR.n198 VPWR.t127 36.0585
R651 VPWR.n190 VPWR.t54 36.0585
R652 VPWR.n477 VPWR.t138 36.0585
R653 VPWR.n702 VPWR.n6 35.3887
R654 VPWR.n666 VPWR.n665 35.3887
R655 VPWR.n630 VPWR.n629 35.3887
R656 VPWR.n594 VPWR.n593 35.3887
R657 VPWR.n558 VPWR.n557 35.3887
R658 VPWR.n522 VPWR.n521 35.3887
R659 VPWR.n133 VPWR.n98 35.3887
R660 VPWR.n289 VPWR.n288 35.3887
R661 VPWR.n302 VPWR.n301 35.3887
R662 VPWR.n332 VPWR.n331 35.3887
R663 VPWR.n354 VPWR.n201 35.3887
R664 VPWR.n397 VPWR.n184 35.3887
R665 VPWR.n408 VPWR.n179 35.3887
R666 VPWR.n444 VPWR.n443 35.3887
R667 VPWR.n483 VPWR.n482 35.3887
R668 VPWR.n103 VPWR.t175 35.1791
R669 VPWR.n685 VPWR.t178 35.1791
R670 VPWR.n25 VPWR.t225 35.1791
R671 VPWR.n40 VPWR.t96 35.1791
R672 VPWR.n55 VPWR.t171 35.1791
R673 VPWR.n70 VPWR.t323 35.1791
R674 VPWR.n85 VPWR.t196 35.1791
R675 VPWR.n171 VPWR.t334 35.1791
R676 VPWR.n154 VPWR.t60 35.1791
R677 VPWR.n268 VPWR.n235 34.6358
R678 VPWR.n713 VPWR.n2 33.7992
R679 VPWR.n677 VPWR.n14 33.7992
R680 VPWR.n641 VPWR.n640 33.7992
R681 VPWR.n605 VPWR.n604 33.7992
R682 VPWR.n569 VPWR.n568 33.7992
R683 VPWR.n533 VPWR.n532 33.7992
R684 VPWR.n497 VPWR.n496 33.7992
R685 VPWR.n419 VPWR.n174 33.7992
R686 VPWR.n455 VPWR.n454 33.7992
R687 VPWR.n489 VPWR.n145 33.1299
R688 VPWR.n264 VPWR.n235 33.1299
R689 VPWR.n288 VPWR.n228 33.1299
R690 VPWR.n307 VPWR.n218 33.1299
R691 VPWR.n331 VPWR.n211 33.1299
R692 VPWR.n350 VPWR.n201 33.1299
R693 VPWR.n367 VPWR.n196 33.1299
R694 VPWR.n374 VPWR.n194 33.1299
R695 VPWR.n393 VPWR.n184 33.1299
R696 VPWR.n114 VPWR.n113 32.377
R697 VPWR.n684 VPWR.n683 32.377
R698 VPWR.n648 VPWR.n647 32.377
R699 VPWR.n612 VPWR.n611 32.377
R700 VPWR.n576 VPWR.n575 32.377
R701 VPWR.n540 VPWR.n539 32.377
R702 VPWR.n504 VPWR.n503 32.377
R703 VPWR.n429 VPWR.n172 32.377
R704 VPWR.n462 VPWR.n461 32.377
R705 VPWR.n693 VPWR.n8 32.0005
R706 VPWR.n659 VPWR.n658 32.0005
R707 VPWR.n623 VPWR.n622 32.0005
R708 VPWR.n587 VPWR.n586 32.0005
R709 VPWR.n551 VPWR.n550 32.0005
R710 VPWR.n515 VPWR.n514 32.0005
R711 VPWR.n124 VPWR.n100 32.0005
R712 VPWR.n254 VPWR.n239 32.0005
R713 VPWR.n277 VPWR.n276 32.0005
R714 VPWR.n297 VPWR.n222 32.0005
R715 VPWR.n320 VPWR.n319 32.0005
R716 VPWR.n340 VPWR.n205 32.0005
R717 VPWR.n363 VPWR.n362 32.0005
R718 VPWR.n383 VPWR.n188 32.0005
R719 VPWR.n399 VPWR.n181 32.0005
R720 VPWR.n437 VPWR.n436 32.0005
R721 VPWR.n478 VPWR.n148 32.0005
R722 VPWR.n703 VPWR.n702 31.2225
R723 VPWR.n667 VPWR.n666 31.2225
R724 VPWR.n631 VPWR.n630 31.2225
R725 VPWR.n595 VPWR.n594 31.2225
R726 VPWR.n559 VPWR.n558 31.2225
R727 VPWR.n523 VPWR.n522 31.2225
R728 VPWR.n134 VPWR.n133 31.2225
R729 VPWR.n409 VPWR.n408 31.2225
R730 VPWR.n445 VPWR.n444 31.2225
R731 VPWR.n488 VPWR.t11 30.9991
R732 VPWR.n237 VPWR.t20 30.9991
R733 VPWR.n227 VPWR.t115 30.9991
R734 VPWR.n220 VPWR.t92 30.9991
R735 VPWR.n210 VPWR.t23 30.9991
R736 VPWR.n203 VPWR.t94 30.9991
R737 VPWR.n193 VPWR.t164 30.9991
R738 VPWR.n186 VPWR.t4 30.9991
R739 VPWR.n692 VPWR.t270 29.6087
R740 VPWR.n657 VPWR.t258 29.6087
R741 VPWR.n621 VPWR.t262 29.6087
R742 VPWR.n585 VPWR.t268 29.6087
R743 VPWR.n549 VPWR.t264 29.6087
R744 VPWR.n513 VPWR.t254 29.6087
R745 VPWR.n123 VPWR.t256 29.6087
R746 VPWR.n183 VPWR.t266 29.6087
R747 VPWR.n168 VPWR.t260 29.6087
R748 VPWR.n686 VPWR.n10 28.6123
R749 VPWR.n652 VPWR.n26 28.6123
R750 VPWR.n616 VPWR.n41 28.6123
R751 VPWR.n580 VPWR.n56 28.6123
R752 VPWR.n544 VPWR.n71 28.6123
R753 VPWR.n508 VPWR.n86 28.6123
R754 VPWR.n388 VPWR.n387 28.6123
R755 VPWR.n431 VPWR.n430 28.6123
R756 VPWR.n463 VPWR.n152 28.6123
R757 VPWR.n5 VPWR.t250 26.3844
R758 VPWR.n5 VPWR.t330 26.3844
R759 VPWR.n21 VPWR.t236 26.3844
R760 VPWR.n21 VPWR.t52 26.3844
R761 VPWR.n36 VPWR.t246 26.3844
R762 VPWR.n36 VPWR.t294 26.3844
R763 VPWR.n51 VPWR.t244 26.3844
R764 VPWR.n51 VPWR.t28 26.3844
R765 VPWR.n66 VPWR.t238 26.3844
R766 VPWR.n66 VPWR.t306 26.3844
R767 VPWR.n81 VPWR.t242 26.3844
R768 VPWR.n81 VPWR.t38 26.3844
R769 VPWR.n97 VPWR.t240 26.3844
R770 VPWR.n97 VPWR.t304 26.3844
R771 VPWR.n178 VPWR.t248 26.3844
R772 VPWR.n178 VPWR.t70 26.3844
R773 VPWR.n164 VPWR.t252 26.3844
R774 VPWR.n164 VPWR.t326 26.3844
R775 VPWR.n466 VPWR.n152 24.8476
R776 VPWR.n469 VPWR.n468 24.8476
R777 VPWR.n121 VPWR.n118 24.0946
R778 VPWR.n705 VPWR.n704 23.6596
R779 VPWR.n20 VPWR.n18 23.6596
R780 VPWR.n35 VPWR.n33 23.6596
R781 VPWR.n50 VPWR.n48 23.6596
R782 VPWR.n65 VPWR.n63 23.6596
R783 VPWR.n80 VPWR.n78 23.6596
R784 VPWR.n136 VPWR.n135 23.6596
R785 VPWR.n411 VPWR.n410 23.6596
R786 VPWR.n163 VPWR.n161 23.6596
R787 VPWR.n712 VPWR.n710 19.7527
R788 VPWR.n673 VPWR.n17 19.7527
R789 VPWR.n637 VPWR.n31 19.7527
R790 VPWR.n601 VPWR.n46 19.7527
R791 VPWR.n565 VPWR.n61 19.7527
R792 VPWR.n529 VPWR.n76 19.7527
R793 VPWR.n141 VPWR.n91 19.7527
R794 VPWR.n418 VPWR.n416 19.7527
R795 VPWR.n451 VPWR.n159 19.7527
R796 VPWR.n115 VPWR.n114 18.824
R797 VPWR.n686 VPWR.n684 18.824
R798 VPWR.n648 VPWR.n26 18.824
R799 VPWR.n612 VPWR.n41 18.824
R800 VPWR.n576 VPWR.n56 18.824
R801 VPWR.n540 VPWR.n71 18.824
R802 VPWR.n504 VPWR.n86 18.824
R803 VPWR.n430 VPWR.n429 18.824
R804 VPWR.n463 VPWR.n462 18.824
R805 VPWR.n693 VPWR.n691 15.4358
R806 VPWR.n658 VPWR.n24 15.4358
R807 VPWR.n622 VPWR.n39 15.4358
R808 VPWR.n586 VPWR.n54 15.4358
R809 VPWR.n550 VPWR.n69 15.4358
R810 VPWR.n514 VPWR.n84 15.4358
R811 VPWR.n124 VPWR.n122 15.4358
R812 VPWR.n399 VPWR.n398 15.4358
R813 VPWR.n436 VPWR.n435 15.4358
R814 VPWR.n113 VPWR.n112 15.0593
R815 VPWR.n683 VPWR.n12 15.0593
R816 VPWR.n647 VPWR.n646 15.0593
R817 VPWR.n611 VPWR.n610 15.0593
R818 VPWR.n575 VPWR.n574 15.0593
R819 VPWR.n539 VPWR.n538 15.0593
R820 VPWR.n503 VPWR.n502 15.0593
R821 VPWR.n425 VPWR.n172 15.0593
R822 VPWR.n461 VPWR.n460 15.0593
R823 VPWR.n489 VPWR.n487 14.3064
R824 VPWR.n264 VPWR.n263 14.3064
R825 VPWR.n284 VPWR.n228 14.3064
R826 VPWR.n307 VPWR.n306 14.3064
R827 VPWR.n327 VPWR.n211 14.3064
R828 VPWR.n350 VPWR.n349 14.3064
R829 VPWR.n370 VPWR.n194 14.3064
R830 VPWR.n393 VPWR.n392 14.3064
R831 VPWR.n493 VPWR.n492 10.5397
R832 VPWR.n466 VPWR 9.36172
R833 VPWR.n714 VPWR.n713 9.3005
R834 VPWR.n106 VPWR.n2 9.3005
R835 VPWR.n109 VPWR.n108 9.3005
R836 VPWR.n110 VPWR.n105 9.3005
R837 VPWR.n112 VPWR.n111 9.3005
R838 VPWR.n113 VPWR.n104 9.3005
R839 VPWR.n114 VPWR.n102 9.3005
R840 VPWR.n119 VPWR.n118 9.3005
R841 VPWR.n121 VPWR.n120 9.3005
R842 VPWR.n122 VPWR.n101 9.3005
R843 VPWR.n125 VPWR.n124 9.3005
R844 VPWR.n126 VPWR.n100 9.3005
R845 VPWR.n128 VPWR.n127 9.3005
R846 VPWR.n129 VPWR.n99 9.3005
R847 VPWR.n131 VPWR.n130 9.3005
R848 VPWR.n133 VPWR.n132 9.3005
R849 VPWR.n134 VPWR.n96 9.3005
R850 VPWR.n137 VPWR.n136 9.3005
R851 VPWR.n138 VPWR.n94 9.3005
R852 VPWR.n140 VPWR.n139 9.3005
R853 VPWR.n142 VPWR.n141 9.3005
R854 VPWR.n496 VPWR.n495 9.3005
R855 VPWR.n497 VPWR.n89 9.3005
R856 VPWR.n499 VPWR.n498 9.3005
R857 VPWR.n500 VPWR.n88 9.3005
R858 VPWR.n502 VPWR.n501 9.3005
R859 VPWR.n503 VPWR.n87 9.3005
R860 VPWR.n505 VPWR.n504 9.3005
R861 VPWR.n506 VPWR.n86 9.3005
R862 VPWR.n508 VPWR.n507 9.3005
R863 VPWR.n510 VPWR.n509 9.3005
R864 VPWR.n511 VPWR.n84 9.3005
R865 VPWR.n514 VPWR.n512 9.3005
R866 VPWR.n515 VPWR.n83 9.3005
R867 VPWR.n517 VPWR.n516 9.3005
R868 VPWR.n518 VPWR.n82 9.3005
R869 VPWR.n520 VPWR.n519 9.3005
R870 VPWR.n522 VPWR.n79 9.3005
R871 VPWR.n524 VPWR.n523 9.3005
R872 VPWR.n525 VPWR.n78 9.3005
R873 VPWR.n527 VPWR.n526 9.3005
R874 VPWR.n528 VPWR.n77 9.3005
R875 VPWR.n530 VPWR.n529 9.3005
R876 VPWR.n532 VPWR.n531 9.3005
R877 VPWR.n533 VPWR.n74 9.3005
R878 VPWR.n535 VPWR.n534 9.3005
R879 VPWR.n536 VPWR.n73 9.3005
R880 VPWR.n538 VPWR.n537 9.3005
R881 VPWR.n539 VPWR.n72 9.3005
R882 VPWR.n541 VPWR.n540 9.3005
R883 VPWR.n542 VPWR.n71 9.3005
R884 VPWR.n544 VPWR.n543 9.3005
R885 VPWR.n546 VPWR.n545 9.3005
R886 VPWR.n547 VPWR.n69 9.3005
R887 VPWR.n550 VPWR.n548 9.3005
R888 VPWR.n551 VPWR.n68 9.3005
R889 VPWR.n553 VPWR.n552 9.3005
R890 VPWR.n554 VPWR.n67 9.3005
R891 VPWR.n556 VPWR.n555 9.3005
R892 VPWR.n558 VPWR.n64 9.3005
R893 VPWR.n560 VPWR.n559 9.3005
R894 VPWR.n561 VPWR.n63 9.3005
R895 VPWR.n563 VPWR.n562 9.3005
R896 VPWR.n564 VPWR.n62 9.3005
R897 VPWR.n566 VPWR.n565 9.3005
R898 VPWR.n568 VPWR.n567 9.3005
R899 VPWR.n569 VPWR.n59 9.3005
R900 VPWR.n571 VPWR.n570 9.3005
R901 VPWR.n572 VPWR.n58 9.3005
R902 VPWR.n574 VPWR.n573 9.3005
R903 VPWR.n575 VPWR.n57 9.3005
R904 VPWR.n577 VPWR.n576 9.3005
R905 VPWR.n578 VPWR.n56 9.3005
R906 VPWR.n580 VPWR.n579 9.3005
R907 VPWR.n582 VPWR.n581 9.3005
R908 VPWR.n583 VPWR.n54 9.3005
R909 VPWR.n586 VPWR.n584 9.3005
R910 VPWR.n587 VPWR.n53 9.3005
R911 VPWR.n589 VPWR.n588 9.3005
R912 VPWR.n590 VPWR.n52 9.3005
R913 VPWR.n592 VPWR.n591 9.3005
R914 VPWR.n594 VPWR.n49 9.3005
R915 VPWR.n596 VPWR.n595 9.3005
R916 VPWR.n597 VPWR.n48 9.3005
R917 VPWR.n599 VPWR.n598 9.3005
R918 VPWR.n600 VPWR.n47 9.3005
R919 VPWR.n602 VPWR.n601 9.3005
R920 VPWR.n604 VPWR.n603 9.3005
R921 VPWR.n605 VPWR.n44 9.3005
R922 VPWR.n607 VPWR.n606 9.3005
R923 VPWR.n608 VPWR.n43 9.3005
R924 VPWR.n610 VPWR.n609 9.3005
R925 VPWR.n611 VPWR.n42 9.3005
R926 VPWR.n613 VPWR.n612 9.3005
R927 VPWR.n614 VPWR.n41 9.3005
R928 VPWR.n616 VPWR.n615 9.3005
R929 VPWR.n618 VPWR.n617 9.3005
R930 VPWR.n619 VPWR.n39 9.3005
R931 VPWR.n622 VPWR.n620 9.3005
R932 VPWR.n623 VPWR.n38 9.3005
R933 VPWR.n625 VPWR.n624 9.3005
R934 VPWR.n626 VPWR.n37 9.3005
R935 VPWR.n628 VPWR.n627 9.3005
R936 VPWR.n630 VPWR.n34 9.3005
R937 VPWR.n632 VPWR.n631 9.3005
R938 VPWR.n633 VPWR.n33 9.3005
R939 VPWR.n635 VPWR.n634 9.3005
R940 VPWR.n636 VPWR.n32 9.3005
R941 VPWR.n638 VPWR.n637 9.3005
R942 VPWR.n640 VPWR.n639 9.3005
R943 VPWR.n641 VPWR.n29 9.3005
R944 VPWR.n643 VPWR.n642 9.3005
R945 VPWR.n644 VPWR.n28 9.3005
R946 VPWR.n646 VPWR.n645 9.3005
R947 VPWR.n647 VPWR.n27 9.3005
R948 VPWR.n649 VPWR.n648 9.3005
R949 VPWR.n650 VPWR.n26 9.3005
R950 VPWR.n652 VPWR.n651 9.3005
R951 VPWR.n654 VPWR.n653 9.3005
R952 VPWR.n655 VPWR.n24 9.3005
R953 VPWR.n658 VPWR.n656 9.3005
R954 VPWR.n659 VPWR.n23 9.3005
R955 VPWR.n661 VPWR.n660 9.3005
R956 VPWR.n662 VPWR.n22 9.3005
R957 VPWR.n664 VPWR.n663 9.3005
R958 VPWR.n666 VPWR.n19 9.3005
R959 VPWR.n668 VPWR.n667 9.3005
R960 VPWR.n669 VPWR.n18 9.3005
R961 VPWR.n671 VPWR.n670 9.3005
R962 VPWR.n672 VPWR.n15 9.3005
R963 VPWR.n674 VPWR.n673 9.3005
R964 VPWR.n675 VPWR.n14 9.3005
R965 VPWR.n677 VPWR.n676 9.3005
R966 VPWR.n678 VPWR.n13 9.3005
R967 VPWR.n680 VPWR.n679 9.3005
R968 VPWR.n681 VPWR.n12 9.3005
R969 VPWR.n683 VPWR.n682 9.3005
R970 VPWR.n684 VPWR.n11 9.3005
R971 VPWR.n687 VPWR.n686 9.3005
R972 VPWR.n688 VPWR.n10 9.3005
R973 VPWR.n690 VPWR.n689 9.3005
R974 VPWR.n691 VPWR.n9 9.3005
R975 VPWR.n694 VPWR.n693 9.3005
R976 VPWR.n695 VPWR.n8 9.3005
R977 VPWR.n697 VPWR.n696 9.3005
R978 VPWR.n698 VPWR.n7 9.3005
R979 VPWR.n700 VPWR.n699 9.3005
R980 VPWR.n702 VPWR.n701 9.3005
R981 VPWR.n703 VPWR.n4 9.3005
R982 VPWR.n706 VPWR.n705 9.3005
R983 VPWR.n707 VPWR.n3 9.3005
R984 VPWR.n709 VPWR.n708 9.3005
R985 VPWR.n710 VPWR.n0 9.3005
R986 VPWR.n145 VPWR.n143 9.3005
R987 VPWR.n246 VPWR.n245 9.3005
R988 VPWR.n249 VPWR.n248 9.3005
R989 VPWR.n250 VPWR.n242 9.3005
R990 VPWR.n252 VPWR.n251 9.3005
R991 VPWR.n253 VPWR.n240 9.3005
R992 VPWR.n255 VPWR.n254 9.3005
R993 VPWR.n256 VPWR.n239 9.3005
R994 VPWR.n258 VPWR.n257 9.3005
R995 VPWR.n260 VPWR.n259 9.3005
R996 VPWR.n262 VPWR.n261 9.3005
R997 VPWR.n263 VPWR.n236 9.3005
R998 VPWR.n265 VPWR.n264 9.3005
R999 VPWR.n266 VPWR.n235 9.3005
R1000 VPWR.n268 VPWR.n267 9.3005
R1001 VPWR.n270 VPWR.n234 9.3005
R1002 VPWR.n272 VPWR.n271 9.3005
R1003 VPWR.n273 VPWR.n233 9.3005
R1004 VPWR.n275 VPWR.n274 9.3005
R1005 VPWR.n276 VPWR.n231 9.3005
R1006 VPWR.n278 VPWR.n277 9.3005
R1007 VPWR.n279 VPWR.n230 9.3005
R1008 VPWR.n281 VPWR.n280 9.3005
R1009 VPWR.n283 VPWR.n229 9.3005
R1010 VPWR.n285 VPWR.n284 9.3005
R1011 VPWR.n286 VPWR.n228 9.3005
R1012 VPWR.n288 VPWR.n287 9.3005
R1013 VPWR.n289 VPWR.n226 9.3005
R1014 VPWR.n292 VPWR.n291 9.3005
R1015 VPWR.n293 VPWR.n225 9.3005
R1016 VPWR.n295 VPWR.n294 9.3005
R1017 VPWR.n296 VPWR.n223 9.3005
R1018 VPWR.n298 VPWR.n297 9.3005
R1019 VPWR.n299 VPWR.n222 9.3005
R1020 VPWR.n301 VPWR.n300 9.3005
R1021 VPWR.n303 VPWR.n302 9.3005
R1022 VPWR.n305 VPWR.n304 9.3005
R1023 VPWR.n306 VPWR.n219 9.3005
R1024 VPWR.n308 VPWR.n307 9.3005
R1025 VPWR.n309 VPWR.n218 9.3005
R1026 VPWR.n311 VPWR.n310 9.3005
R1027 VPWR.n313 VPWR.n217 9.3005
R1028 VPWR.n315 VPWR.n314 9.3005
R1029 VPWR.n316 VPWR.n216 9.3005
R1030 VPWR.n318 VPWR.n317 9.3005
R1031 VPWR.n319 VPWR.n214 9.3005
R1032 VPWR.n321 VPWR.n320 9.3005
R1033 VPWR.n322 VPWR.n213 9.3005
R1034 VPWR.n324 VPWR.n323 9.3005
R1035 VPWR.n326 VPWR.n212 9.3005
R1036 VPWR.n328 VPWR.n327 9.3005
R1037 VPWR.n329 VPWR.n211 9.3005
R1038 VPWR.n331 VPWR.n330 9.3005
R1039 VPWR.n332 VPWR.n209 9.3005
R1040 VPWR.n335 VPWR.n334 9.3005
R1041 VPWR.n336 VPWR.n208 9.3005
R1042 VPWR.n338 VPWR.n337 9.3005
R1043 VPWR.n339 VPWR.n206 9.3005
R1044 VPWR.n341 VPWR.n340 9.3005
R1045 VPWR.n342 VPWR.n205 9.3005
R1046 VPWR.n344 VPWR.n343 9.3005
R1047 VPWR.n346 VPWR.n345 9.3005
R1048 VPWR.n348 VPWR.n347 9.3005
R1049 VPWR.n349 VPWR.n202 9.3005
R1050 VPWR.n351 VPWR.n350 9.3005
R1051 VPWR.n352 VPWR.n201 9.3005
R1052 VPWR.n354 VPWR.n353 9.3005
R1053 VPWR.n356 VPWR.n200 9.3005
R1054 VPWR.n358 VPWR.n357 9.3005
R1055 VPWR.n359 VPWR.n199 9.3005
R1056 VPWR.n361 VPWR.n360 9.3005
R1057 VPWR.n362 VPWR.n197 9.3005
R1058 VPWR.n364 VPWR.n363 9.3005
R1059 VPWR.n365 VPWR.n196 9.3005
R1060 VPWR.n367 VPWR.n366 9.3005
R1061 VPWR.n369 VPWR.n195 9.3005
R1062 VPWR.n371 VPWR.n370 9.3005
R1063 VPWR.n372 VPWR.n194 9.3005
R1064 VPWR.n374 VPWR.n373 9.3005
R1065 VPWR.n375 VPWR.n192 9.3005
R1066 VPWR.n378 VPWR.n377 9.3005
R1067 VPWR.n379 VPWR.n191 9.3005
R1068 VPWR.n381 VPWR.n380 9.3005
R1069 VPWR.n382 VPWR.n189 9.3005
R1070 VPWR.n384 VPWR.n383 9.3005
R1071 VPWR.n385 VPWR.n188 9.3005
R1072 VPWR.n387 VPWR.n386 9.3005
R1073 VPWR.n389 VPWR.n388 9.3005
R1074 VPWR.n391 VPWR.n390 9.3005
R1075 VPWR.n392 VPWR.n185 9.3005
R1076 VPWR.n394 VPWR.n393 9.3005
R1077 VPWR.n395 VPWR.n184 9.3005
R1078 VPWR.n397 VPWR.n396 9.3005
R1079 VPWR.n398 VPWR.n182 9.3005
R1080 VPWR.n400 VPWR.n399 9.3005
R1081 VPWR.n401 VPWR.n181 9.3005
R1082 VPWR.n403 VPWR.n402 9.3005
R1083 VPWR.n404 VPWR.n180 9.3005
R1084 VPWR.n406 VPWR.n405 9.3005
R1085 VPWR.n408 VPWR.n407 9.3005
R1086 VPWR.n409 VPWR.n177 9.3005
R1087 VPWR.n412 VPWR.n411 9.3005
R1088 VPWR.n413 VPWR.n176 9.3005
R1089 VPWR.n415 VPWR.n414 9.3005
R1090 VPWR.n416 VPWR.n175 9.3005
R1091 VPWR.n420 VPWR.n419 9.3005
R1092 VPWR.n421 VPWR.n174 9.3005
R1093 VPWR.n423 VPWR.n422 9.3005
R1094 VPWR.n424 VPWR.n173 9.3005
R1095 VPWR.n426 VPWR.n425 9.3005
R1096 VPWR.n427 VPWR.n172 9.3005
R1097 VPWR.n429 VPWR.n428 9.3005
R1098 VPWR.n430 VPWR.n170 9.3005
R1099 VPWR.n432 VPWR.n431 9.3005
R1100 VPWR.n433 VPWR.n169 9.3005
R1101 VPWR.n435 VPWR.n434 9.3005
R1102 VPWR.n436 VPWR.n167 9.3005
R1103 VPWR.n437 VPWR.n166 9.3005
R1104 VPWR.n439 VPWR.n438 9.3005
R1105 VPWR.n440 VPWR.n165 9.3005
R1106 VPWR.n442 VPWR.n441 9.3005
R1107 VPWR.n444 VPWR.n162 9.3005
R1108 VPWR.n446 VPWR.n445 9.3005
R1109 VPWR.n447 VPWR.n161 9.3005
R1110 VPWR.n449 VPWR.n448 9.3005
R1111 VPWR.n450 VPWR.n160 9.3005
R1112 VPWR.n452 VPWR.n451 9.3005
R1113 VPWR.n454 VPWR.n453 9.3005
R1114 VPWR.n455 VPWR.n157 9.3005
R1115 VPWR.n457 VPWR.n456 9.3005
R1116 VPWR.n458 VPWR.n156 9.3005
R1117 VPWR.n460 VPWR.n459 9.3005
R1118 VPWR.n461 VPWR.n155 9.3005
R1119 VPWR.n462 VPWR.n153 9.3005
R1120 VPWR.n464 VPWR.n463 9.3005
R1121 VPWR.n465 VPWR.n152 9.3005
R1122 VPWR.n468 VPWR.n467 9.3005
R1123 VPWR.n469 VPWR.n151 9.3005
R1124 VPWR.n472 VPWR.n471 9.3005
R1125 VPWR.n473 VPWR.n150 9.3005
R1126 VPWR.n475 VPWR.n474 9.3005
R1127 VPWR.n476 VPWR.n149 9.3005
R1128 VPWR.n479 VPWR.n478 9.3005
R1129 VPWR.n480 VPWR.n148 9.3005
R1130 VPWR.n482 VPWR.n481 9.3005
R1131 VPWR.n484 VPWR.n483 9.3005
R1132 VPWR.n485 VPWR.n146 9.3005
R1133 VPWR.n487 VPWR.n486 9.3005
R1134 VPWR.n490 VPWR.n489 9.3005
R1135 VPWR.n259 VPWR.n238 8.28285
R1136 VPWR.n282 VPWR.n281 8.28285
R1137 VPWR.n302 VPWR.n221 8.28285
R1138 VPWR.n325 VPWR.n324 8.28285
R1139 VPWR.n345 VPWR.n204 8.28285
R1140 VPWR.n368 VPWR.n367 8.28285
R1141 VPWR.n388 VPWR.n187 8.28285
R1142 VPWR.n483 VPWR.n147 8.28285
R1143 VPWR.n116 VPWR.n115 7.44972
R1144 VPWR.n254 VPWR.n253 7.15344
R1145 VPWR.n276 VPWR.n275 7.15344
R1146 VPWR.n297 VPWR.n296 7.15344
R1147 VPWR.n319 VPWR.n318 7.15344
R1148 VPWR.n340 VPWR.n339 7.15344
R1149 VPWR.n362 VPWR.n361 7.15344
R1150 VPWR.n383 VPWR.n382 7.15344
R1151 VPWR.n478 VPWR.n476 7.15344
R1152 VPWR.n247 VPWR.n246 6.4005
R1153 VPWR.n269 VPWR.n268 6.4005
R1154 VPWR.n290 VPWR.n289 6.4005
R1155 VPWR.n312 VPWR.n311 6.4005
R1156 VPWR.n333 VPWR.n332 6.4005
R1157 VPWR.n355 VPWR.n354 6.4005
R1158 VPWR.n376 VPWR.n375 6.4005
R1159 VPWR.n470 VPWR.n469 6.4005
R1160 VPWR.n248 VPWR.n247 4.89462
R1161 VPWR.n270 VPWR.n269 4.89462
R1162 VPWR.n291 VPWR.n290 4.89462
R1163 VPWR.n313 VPWR.n312 4.89462
R1164 VPWR.n334 VPWR.n333 4.89462
R1165 VPWR.n356 VPWR.n355 4.89462
R1166 VPWR.n377 VPWR.n376 4.89462
R1167 VPWR.n471 VPWR.n470 4.89462
R1168 VPWR.n713 VPWR.n712 3.27161
R1169 VPWR.n17 VPWR.n14 3.27161
R1170 VPWR.n640 VPWR.n31 3.27161
R1171 VPWR.n604 VPWR.n46 3.27161
R1172 VPWR.n568 VPWR.n61 3.27161
R1173 VPWR.n532 VPWR.n76 3.27161
R1174 VPWR.n496 VPWR.n91 3.27161
R1175 VPWR.n419 VPWR.n418 3.27161
R1176 VPWR.n454 VPWR.n159 3.27161
R1177 VPWR.n147 VPWR.n146 2.63579
R1178 VPWR.n262 VPWR.n238 2.63579
R1179 VPWR.n283 VPWR.n282 2.63579
R1180 VPWR.n305 VPWR.n221 2.63579
R1181 VPWR.n326 VPWR.n325 2.63579
R1182 VPWR.n348 VPWR.n204 2.63579
R1183 VPWR.n369 VPWR.n368 2.63579
R1184 VPWR.n391 VPWR.n187 2.63579
R1185 VPWR.n704 VPWR.n703 1.70717
R1186 VPWR.n667 VPWR.n20 1.70717
R1187 VPWR.n631 VPWR.n35 1.70717
R1188 VPWR.n595 VPWR.n50 1.70717
R1189 VPWR.n559 VPWR.n65 1.70717
R1190 VPWR.n523 VPWR.n80 1.70717
R1191 VPWR.n135 VPWR.n134 1.70717
R1192 VPWR.n410 VPWR.n409 1.70717
R1193 VPWR.n445 VPWR.n163 1.70717
R1194 VPWR.n1 VPWR 1.54858
R1195 VPWR.n107 VPWR 1.24285
R1196 VPWR.n92 VPWR 1.1204
R1197 VPWR.n494 VPWR 1.0105
R1198 VPWR VPWR.n715 0.895108
R1199 VPWR.n93 VPWR 0.839442
R1200 VPWR.n95 VPWR 0.8105
R1201 VPWR.n699 VPWR.n6 0.753441
R1202 VPWR.n665 VPWR.n664 0.753441
R1203 VPWR.n629 VPWR.n628 0.753441
R1204 VPWR.n593 VPWR.n592 0.753441
R1205 VPWR.n557 VPWR.n556 0.753441
R1206 VPWR.n521 VPWR.n520 0.753441
R1207 VPWR.n130 VPWR.n98 0.753441
R1208 VPWR.n405 VPWR.n179 0.753441
R1209 VPWR.n443 VPWR.n442 0.753441
R1210 VPWR.n244 VPWR 0.588
R1211 VPWR.n491 VPWR 0.433192
R1212 VPWR.n144 VPWR 0.383
R1213 VPWR.n117 VPWR.n116 0.238424
R1214 VPWR.n116 VPWR.n102 0.147507
R1215 VPWR.n110 VPWR.n109 0.122949
R1216 VPWR.n111 VPWR.n110 0.122949
R1217 VPWR.n111 VPWR.n104 0.122949
R1218 VPWR.n104 VPWR.n102 0.122949
R1219 VPWR.n120 VPWR.n101 0.122949
R1220 VPWR.n125 VPWR.n101 0.122949
R1221 VPWR.n126 VPWR.n125 0.122949
R1222 VPWR.n127 VPWR.n126 0.122949
R1223 VPWR.n131 VPWR.n99 0.122949
R1224 VPWR.n132 VPWR.n131 0.122949
R1225 VPWR.n132 VPWR.n96 0.122949
R1226 VPWR.n137 VPWR.n96 0.122949
R1227 VPWR.n138 VPWR.n137 0.122949
R1228 VPWR.n139 VPWR.n138 0.122949
R1229 VPWR.n499 VPWR.n89 0.122949
R1230 VPWR.n500 VPWR.n499 0.122949
R1231 VPWR.n501 VPWR.n500 0.122949
R1232 VPWR.n501 VPWR.n87 0.122949
R1233 VPWR.n505 VPWR.n87 0.122949
R1234 VPWR.n506 VPWR.n505 0.122949
R1235 VPWR.n507 VPWR.n506 0.122949
R1236 VPWR.n511 VPWR.n510 0.122949
R1237 VPWR.n512 VPWR.n511 0.122949
R1238 VPWR.n512 VPWR.n83 0.122949
R1239 VPWR.n517 VPWR.n83 0.122949
R1240 VPWR.n519 VPWR.n518 0.122949
R1241 VPWR.n519 VPWR.n79 0.122949
R1242 VPWR.n524 VPWR.n79 0.122949
R1243 VPWR.n525 VPWR.n524 0.122949
R1244 VPWR.n526 VPWR.n525 0.122949
R1245 VPWR.n526 VPWR.n77 0.122949
R1246 VPWR.n530 VPWR.n77 0.122949
R1247 VPWR.n531 VPWR.n530 0.122949
R1248 VPWR.n531 VPWR.n74 0.122949
R1249 VPWR.n535 VPWR.n74 0.122949
R1250 VPWR.n536 VPWR.n535 0.122949
R1251 VPWR.n537 VPWR.n536 0.122949
R1252 VPWR.n537 VPWR.n72 0.122949
R1253 VPWR.n541 VPWR.n72 0.122949
R1254 VPWR.n542 VPWR.n541 0.122949
R1255 VPWR.n543 VPWR.n542 0.122949
R1256 VPWR.n547 VPWR.n546 0.122949
R1257 VPWR.n548 VPWR.n547 0.122949
R1258 VPWR.n548 VPWR.n68 0.122949
R1259 VPWR.n553 VPWR.n68 0.122949
R1260 VPWR.n555 VPWR.n554 0.122949
R1261 VPWR.n555 VPWR.n64 0.122949
R1262 VPWR.n560 VPWR.n64 0.122949
R1263 VPWR.n561 VPWR.n560 0.122949
R1264 VPWR.n562 VPWR.n561 0.122949
R1265 VPWR.n562 VPWR.n62 0.122949
R1266 VPWR.n566 VPWR.n62 0.122949
R1267 VPWR.n567 VPWR.n566 0.122949
R1268 VPWR.n567 VPWR.n59 0.122949
R1269 VPWR.n571 VPWR.n59 0.122949
R1270 VPWR.n572 VPWR.n571 0.122949
R1271 VPWR.n573 VPWR.n572 0.122949
R1272 VPWR.n573 VPWR.n57 0.122949
R1273 VPWR.n577 VPWR.n57 0.122949
R1274 VPWR.n578 VPWR.n577 0.122949
R1275 VPWR.n579 VPWR.n578 0.122949
R1276 VPWR.n583 VPWR.n582 0.122949
R1277 VPWR.n584 VPWR.n583 0.122949
R1278 VPWR.n584 VPWR.n53 0.122949
R1279 VPWR.n589 VPWR.n53 0.122949
R1280 VPWR.n591 VPWR.n590 0.122949
R1281 VPWR.n591 VPWR.n49 0.122949
R1282 VPWR.n596 VPWR.n49 0.122949
R1283 VPWR.n597 VPWR.n596 0.122949
R1284 VPWR.n598 VPWR.n597 0.122949
R1285 VPWR.n598 VPWR.n47 0.122949
R1286 VPWR.n602 VPWR.n47 0.122949
R1287 VPWR.n603 VPWR.n602 0.122949
R1288 VPWR.n603 VPWR.n44 0.122949
R1289 VPWR.n607 VPWR.n44 0.122949
R1290 VPWR.n608 VPWR.n607 0.122949
R1291 VPWR.n609 VPWR.n608 0.122949
R1292 VPWR.n609 VPWR.n42 0.122949
R1293 VPWR.n613 VPWR.n42 0.122949
R1294 VPWR.n614 VPWR.n613 0.122949
R1295 VPWR.n615 VPWR.n614 0.122949
R1296 VPWR.n619 VPWR.n618 0.122949
R1297 VPWR.n620 VPWR.n619 0.122949
R1298 VPWR.n620 VPWR.n38 0.122949
R1299 VPWR.n625 VPWR.n38 0.122949
R1300 VPWR.n627 VPWR.n626 0.122949
R1301 VPWR.n627 VPWR.n34 0.122949
R1302 VPWR.n632 VPWR.n34 0.122949
R1303 VPWR.n633 VPWR.n632 0.122949
R1304 VPWR.n634 VPWR.n633 0.122949
R1305 VPWR.n634 VPWR.n32 0.122949
R1306 VPWR.n638 VPWR.n32 0.122949
R1307 VPWR.n639 VPWR.n638 0.122949
R1308 VPWR.n639 VPWR.n29 0.122949
R1309 VPWR.n643 VPWR.n29 0.122949
R1310 VPWR.n644 VPWR.n643 0.122949
R1311 VPWR.n645 VPWR.n644 0.122949
R1312 VPWR.n645 VPWR.n27 0.122949
R1313 VPWR.n649 VPWR.n27 0.122949
R1314 VPWR.n650 VPWR.n649 0.122949
R1315 VPWR.n651 VPWR.n650 0.122949
R1316 VPWR.n655 VPWR.n654 0.122949
R1317 VPWR.n656 VPWR.n655 0.122949
R1318 VPWR.n656 VPWR.n23 0.122949
R1319 VPWR.n661 VPWR.n23 0.122949
R1320 VPWR.n663 VPWR.n662 0.122949
R1321 VPWR.n663 VPWR.n19 0.122949
R1322 VPWR.n668 VPWR.n19 0.122949
R1323 VPWR.n669 VPWR.n668 0.122949
R1324 VPWR.n670 VPWR.n669 0.122949
R1325 VPWR.n670 VPWR.n15 0.122949
R1326 VPWR.n674 VPWR.n15 0.122949
R1327 VPWR.n675 VPWR.n674 0.122949
R1328 VPWR.n676 VPWR.n675 0.122949
R1329 VPWR.n676 VPWR.n13 0.122949
R1330 VPWR.n680 VPWR.n13 0.122949
R1331 VPWR.n681 VPWR.n680 0.122949
R1332 VPWR.n682 VPWR.n681 0.122949
R1333 VPWR.n682 VPWR.n11 0.122949
R1334 VPWR.n687 VPWR.n11 0.122949
R1335 VPWR.n688 VPWR.n687 0.122949
R1336 VPWR.n689 VPWR.n9 0.122949
R1337 VPWR.n694 VPWR.n9 0.122949
R1338 VPWR.n695 VPWR.n694 0.122949
R1339 VPWR.n696 VPWR.n695 0.122949
R1340 VPWR.n700 VPWR.n7 0.122949
R1341 VPWR.n701 VPWR.n700 0.122949
R1342 VPWR.n701 VPWR.n4 0.122949
R1343 VPWR.n706 VPWR.n4 0.122949
R1344 VPWR.n707 VPWR.n706 0.122949
R1345 VPWR.n708 VPWR.n707 0.122949
R1346 VPWR.n708 VPWR.n0 0.122949
R1347 VPWR.n250 VPWR.n249 0.122949
R1348 VPWR.n251 VPWR.n250 0.122949
R1349 VPWR.n251 VPWR.n240 0.122949
R1350 VPWR.n255 VPWR.n240 0.122949
R1351 VPWR.n256 VPWR.n255 0.122949
R1352 VPWR.n257 VPWR.n256 0.122949
R1353 VPWR.n261 VPWR.n260 0.122949
R1354 VPWR.n261 VPWR.n236 0.122949
R1355 VPWR.n265 VPWR.n236 0.122949
R1356 VPWR.n266 VPWR.n265 0.122949
R1357 VPWR.n267 VPWR.n234 0.122949
R1358 VPWR.n272 VPWR.n234 0.122949
R1359 VPWR.n273 VPWR.n272 0.122949
R1360 VPWR.n274 VPWR.n273 0.122949
R1361 VPWR.n274 VPWR.n231 0.122949
R1362 VPWR.n278 VPWR.n231 0.122949
R1363 VPWR.n279 VPWR.n278 0.122949
R1364 VPWR.n280 VPWR.n229 0.122949
R1365 VPWR.n285 VPWR.n229 0.122949
R1366 VPWR.n286 VPWR.n285 0.122949
R1367 VPWR.n287 VPWR.n286 0.122949
R1368 VPWR.n292 VPWR.n226 0.122949
R1369 VPWR.n293 VPWR.n292 0.122949
R1370 VPWR.n294 VPWR.n293 0.122949
R1371 VPWR.n294 VPWR.n223 0.122949
R1372 VPWR.n298 VPWR.n223 0.122949
R1373 VPWR.n299 VPWR.n298 0.122949
R1374 VPWR.n300 VPWR.n299 0.122949
R1375 VPWR.n304 VPWR.n303 0.122949
R1376 VPWR.n304 VPWR.n219 0.122949
R1377 VPWR.n308 VPWR.n219 0.122949
R1378 VPWR.n309 VPWR.n308 0.122949
R1379 VPWR.n310 VPWR.n217 0.122949
R1380 VPWR.n315 VPWR.n217 0.122949
R1381 VPWR.n316 VPWR.n315 0.122949
R1382 VPWR.n317 VPWR.n316 0.122949
R1383 VPWR.n317 VPWR.n214 0.122949
R1384 VPWR.n321 VPWR.n214 0.122949
R1385 VPWR.n322 VPWR.n321 0.122949
R1386 VPWR.n323 VPWR.n212 0.122949
R1387 VPWR.n328 VPWR.n212 0.122949
R1388 VPWR.n329 VPWR.n328 0.122949
R1389 VPWR.n330 VPWR.n329 0.122949
R1390 VPWR.n335 VPWR.n209 0.122949
R1391 VPWR.n336 VPWR.n335 0.122949
R1392 VPWR.n337 VPWR.n336 0.122949
R1393 VPWR.n337 VPWR.n206 0.122949
R1394 VPWR.n341 VPWR.n206 0.122949
R1395 VPWR.n342 VPWR.n341 0.122949
R1396 VPWR.n343 VPWR.n342 0.122949
R1397 VPWR.n347 VPWR.n346 0.122949
R1398 VPWR.n347 VPWR.n202 0.122949
R1399 VPWR.n351 VPWR.n202 0.122949
R1400 VPWR.n352 VPWR.n351 0.122949
R1401 VPWR.n353 VPWR.n200 0.122949
R1402 VPWR.n358 VPWR.n200 0.122949
R1403 VPWR.n359 VPWR.n358 0.122949
R1404 VPWR.n360 VPWR.n359 0.122949
R1405 VPWR.n360 VPWR.n197 0.122949
R1406 VPWR.n364 VPWR.n197 0.122949
R1407 VPWR.n365 VPWR.n364 0.122949
R1408 VPWR.n366 VPWR.n195 0.122949
R1409 VPWR.n371 VPWR.n195 0.122949
R1410 VPWR.n372 VPWR.n371 0.122949
R1411 VPWR.n373 VPWR.n372 0.122949
R1412 VPWR.n378 VPWR.n192 0.122949
R1413 VPWR.n379 VPWR.n378 0.122949
R1414 VPWR.n380 VPWR.n379 0.122949
R1415 VPWR.n380 VPWR.n189 0.122949
R1416 VPWR.n384 VPWR.n189 0.122949
R1417 VPWR.n385 VPWR.n384 0.122949
R1418 VPWR.n386 VPWR.n385 0.122949
R1419 VPWR.n390 VPWR.n389 0.122949
R1420 VPWR.n390 VPWR.n185 0.122949
R1421 VPWR.n394 VPWR.n185 0.122949
R1422 VPWR.n395 VPWR.n394 0.122949
R1423 VPWR.n396 VPWR.n182 0.122949
R1424 VPWR.n400 VPWR.n182 0.122949
R1425 VPWR.n401 VPWR.n400 0.122949
R1426 VPWR.n402 VPWR.n401 0.122949
R1427 VPWR.n406 VPWR.n180 0.122949
R1428 VPWR.n407 VPWR.n406 0.122949
R1429 VPWR.n407 VPWR.n177 0.122949
R1430 VPWR.n412 VPWR.n177 0.122949
R1431 VPWR.n413 VPWR.n412 0.122949
R1432 VPWR.n414 VPWR.n413 0.122949
R1433 VPWR.n414 VPWR.n175 0.122949
R1434 VPWR.n420 VPWR.n175 0.122949
R1435 VPWR.n421 VPWR.n420 0.122949
R1436 VPWR.n422 VPWR.n421 0.122949
R1437 VPWR.n422 VPWR.n173 0.122949
R1438 VPWR.n426 VPWR.n173 0.122949
R1439 VPWR.n427 VPWR.n426 0.122949
R1440 VPWR.n428 VPWR.n427 0.122949
R1441 VPWR.n428 VPWR.n170 0.122949
R1442 VPWR.n432 VPWR.n170 0.122949
R1443 VPWR.n434 VPWR.n433 0.122949
R1444 VPWR.n434 VPWR.n167 0.122949
R1445 VPWR.n167 VPWR.n166 0.122949
R1446 VPWR.n439 VPWR.n166 0.122949
R1447 VPWR.n441 VPWR.n440 0.122949
R1448 VPWR.n441 VPWR.n162 0.122949
R1449 VPWR.n446 VPWR.n162 0.122949
R1450 VPWR.n447 VPWR.n446 0.122949
R1451 VPWR.n448 VPWR.n447 0.122949
R1452 VPWR.n448 VPWR.n160 0.122949
R1453 VPWR.n452 VPWR.n160 0.122949
R1454 VPWR.n453 VPWR.n452 0.122949
R1455 VPWR.n453 VPWR.n157 0.122949
R1456 VPWR.n457 VPWR.n157 0.122949
R1457 VPWR.n458 VPWR.n457 0.122949
R1458 VPWR.n459 VPWR.n458 0.122949
R1459 VPWR.n459 VPWR.n155 0.122949
R1460 VPWR.n155 VPWR.n153 0.122949
R1461 VPWR.n464 VPWR.n153 0.122949
R1462 VPWR.n465 VPWR.n464 0.122949
R1463 VPWR.n472 VPWR.n151 0.122949
R1464 VPWR.n473 VPWR.n472 0.122949
R1465 VPWR.n474 VPWR.n473 0.122949
R1466 VPWR.n474 VPWR.n149 0.122949
R1467 VPWR.n479 VPWR.n149 0.122949
R1468 VPWR.n480 VPWR.n479 0.122949
R1469 VPWR.n481 VPWR.n480 0.122949
R1470 VPWR.n485 VPWR.n484 0.122949
R1471 VPWR.n486 VPWR.n485 0.122949
R1472 VPWR.n249 VPWR.n243 0.112745
R1473 VPWR.n715 VPWR.n714 0.105892
R1474 VPWR.n486 VPWR.n144 0.0846837
R1475 VPWR.n495 VPWR.n92 0.078
R1476 VPWR.n107 VPWR.n106 0.0764804
R1477 VPWR.n106 VPWR.n1 0.0740294
R1478 VPWR.n243 VPWR 0.0719286
R1479 VPWR.n494 VPWR.n493 0.0666058
R1480 VPWR.n492 VPWR.n491 0.0666058
R1481 VPWR.n95 VPWR.n93 0.063
R1482 VPWR.n119 VPWR 0.0617245
R1483 VPWR.n120 VPWR 0.0617245
R1484 VPWR.n127 VPWR 0.0617245
R1485 VPWR VPWR.n99 0.0617245
R1486 VPWR.n507 VPWR 0.0617245
R1487 VPWR.n510 VPWR 0.0617245
R1488 VPWR VPWR.n517 0.0617245
R1489 VPWR.n518 VPWR 0.0617245
R1490 VPWR.n543 VPWR 0.0617245
R1491 VPWR.n546 VPWR 0.0617245
R1492 VPWR VPWR.n553 0.0617245
R1493 VPWR.n554 VPWR 0.0617245
R1494 VPWR.n579 VPWR 0.0617245
R1495 VPWR.n582 VPWR 0.0617245
R1496 VPWR VPWR.n589 0.0617245
R1497 VPWR.n590 VPWR 0.0617245
R1498 VPWR.n615 VPWR 0.0617245
R1499 VPWR.n618 VPWR 0.0617245
R1500 VPWR VPWR.n625 0.0617245
R1501 VPWR.n626 VPWR 0.0617245
R1502 VPWR.n651 VPWR 0.0617245
R1503 VPWR.n654 VPWR 0.0617245
R1504 VPWR VPWR.n661 0.0617245
R1505 VPWR.n662 VPWR 0.0617245
R1506 VPWR VPWR.n688 0.0617245
R1507 VPWR.n689 VPWR 0.0617245
R1508 VPWR.n696 VPWR 0.0617245
R1509 VPWR VPWR.n7 0.0617245
R1510 VPWR.n257 VPWR 0.0617245
R1511 VPWR.n260 VPWR 0.0617245
R1512 VPWR.n267 VPWR 0.0617245
R1513 VPWR VPWR.n279 0.0617245
R1514 VPWR.n280 VPWR 0.0617245
R1515 VPWR VPWR.n226 0.0617245
R1516 VPWR.n303 VPWR 0.0617245
R1517 VPWR VPWR.n309 0.0617245
R1518 VPWR.n310 VPWR 0.0617245
R1519 VPWR VPWR.n322 0.0617245
R1520 VPWR.n323 VPWR 0.0617245
R1521 VPWR VPWR.n209 0.0617245
R1522 VPWR.n343 VPWR 0.0617245
R1523 VPWR.n346 VPWR 0.0617245
R1524 VPWR.n353 VPWR 0.0617245
R1525 VPWR.n366 VPWR 0.0617245
R1526 VPWR.n373 VPWR 0.0617245
R1527 VPWR VPWR.n192 0.0617245
R1528 VPWR.n389 VPWR 0.0617245
R1529 VPWR.n396 VPWR 0.0617245
R1530 VPWR.n402 VPWR 0.0617245
R1531 VPWR VPWR.n180 0.0617245
R1532 VPWR VPWR.n432 0.0617245
R1533 VPWR.n433 VPWR 0.0617245
R1534 VPWR VPWR.n439 0.0617245
R1535 VPWR.n440 VPWR 0.0617245
R1536 VPWR VPWR.n465 0.0617245
R1537 VPWR.n467 VPWR 0.0617245
R1538 VPWR.n467 VPWR 0.0617245
R1539 VPWR VPWR.n151 0.0617245
R1540 VPWR.n484 VPWR 0.0617245
R1541 VPWR.n245 VPWR 0.0605
R1542 VPWR VPWR.n119 0.0591735
R1543 VPWR.n287 VPWR 0.0591735
R1544 VPWR.n300 VPWR 0.0591735
R1545 VPWR.n330 VPWR 0.0591735
R1546 VPWR VPWR.n352 0.0591735
R1547 VPWR VPWR.n395 0.0591735
R1548 VPWR.n481 VPWR 0.0591735
R1549 VPWR VPWR.n266 0.0566224
R1550 VPWR.n117 VPWR 0.0551875
R1551 VPWR VPWR.n365 0.0515204
R1552 VPWR.n244 VPWR.n143 0.0461731
R1553 VPWR.n714 VPWR.n1 0.0446176
R1554 VPWR.n109 VPWR.n107 0.0438673
R1555 VPWR.n92 VPWR.n89 0.0438673
R1556 VPWR.n493 VPWR.n142 0.0401635
R1557 VPWR.n490 VPWR.n144 0.038
R1558 VPWR.n386 VPWR 0.0362143
R1559 VPWR.n139 VPWR.n95 0.0311122
R1560 VPWR.n491 VPWR.n490 0.0305
R1561 VPWR.n142 VPWR.n93 0.0269423
R1562 VPWR.n492 VPWR.n143 0.0209327
R1563 VPWR.n715 VPWR.n0 0.0132551
R1564 VPWR VPWR.n244 0.013
R1565 VPWR.n495 VPWR.n494 0.0105
R1566 VPWR.n245 VPWR.n243 0.0105
R1567 VGND.n484 VGND.n483 49876.3
R1568 VGND.n233 sky130_fd_sc_hs__dfxtp_1_6.VNB 4184.07
R1569 VGND.t310 VGND.t114 2709.26
R1570 VGND.t136 VGND.t227 2709.26
R1571 VGND.t156 VGND.t92 2709.26
R1572 VGND.t11 VGND.t174 2709.26
R1573 VGND.t118 VGND.t124 2709.26
R1574 VGND.t316 VGND.t199 2709.26
R1575 VGND.t170 VGND.t325 2709.26
R1576 VGND.t94 VGND.t186 2666.06
R1577 VGND.t321 VGND.t224 2666.06
R1578 VGND.t212 VGND.t189 2016.67
R1579 VGND.t184 VGND.t98 2016.67
R1580 VGND.t107 VGND.t303 2016.67
R1581 VGND.t172 VGND.t150 2016.67
R1582 VGND.t342 VGND.t54 2016.67
R1583 VGND.t73 VGND.t168 2016.67
R1584 VGND.t166 VGND.t17 1984.51
R1585 VGND.t7 VGND.t90 1984.51
R1586 VGND.t246 sky130_fd_sc_hs__and2_1_0.VGND 1794.08
R1587 VGND.t214 sky130_fd_sc_hs__and2_1_0.VGND 1794.08
R1588 VGND.t294 sky130_fd_sc_hs__and2_1_0.VGND 1794.08
R1589 VGND.t152 sky130_fd_sc_hs__and2_1_0.VGND 1794.08
R1590 VGND.t62 sky130_fd_sc_hs__and2_1_0.VGND 1794.08
R1591 VGND.t28 sky130_fd_sc_hs__and2_1_0.VGND 1794.08
R1592 VGND.t100 sky130_fd_sc_hs__and2_1_0.VGND 1794.08
R1593 VGND.t83 sky130_fd_sc_hs__and2_1_0.VGND 1794.08
R1594 VGND.t130 VGND.t246 1593.62
R1595 VGND.t340 VGND.t214 1593.62
R1596 VGND.t154 VGND.t294 1593.62
R1597 VGND.t229 VGND.t152 1593.62
R1598 VGND.t134 VGND.t62 1593.62
R1599 VGND.t88 VGND.t28 1593.62
R1600 VGND.t19 VGND.t100 1593.62
R1601 VGND.t305 VGND.t83 1593.62
R1602 VGND.n232 VGND.t30 1473.35
R1603 VGND.t331 sky130_fd_sc_hs__and2_1_0.VGND 1466.67
R1604 VGND.t146 sky130_fd_sc_hs__and2_1_0.VGND 1466.67
R1605 VGND.t318 sky130_fd_sc_hs__and2_1_0.VGND 1466.67
R1606 VGND.t210 sky130_fd_sc_hs__and2_1_0.VGND 1466.67
R1607 VGND.t193 sky130_fd_sc_hs__and2_1_0.VGND 1466.67
R1608 VGND.t308 sky130_fd_sc_hs__and2_1_0.VGND 1466.67
R1609 VGND.t182 sky130_fd_sc_hs__and2_1_0.VGND 1466.67
R1610 VGND.t164 sky130_fd_sc_hs__and2_1_0.VGND 1443.28
R1611 VGND.t202 sky130_fd_sc_hs__and2_1_0.VGND 1443.28
R1612 VGND.t195 VGND.t5 1385.19
R1613 VGND.t220 VGND.t85 1385.19
R1614 VGND.t287 VGND.t34 1385.19
R1615 VGND.t25 VGND.t116 1385.19
R1616 VGND.t81 VGND.t79 1385.19
R1617 VGND.t142 VGND.t162 1385.19
R1618 VGND.t216 VGND.t21 1385.19
R1619 sky130_fd_sc_hs__and2_1_0.VGND VGND.t44 1363.1
R1620 sky130_fd_sc_hs__and2_1_0.VGND VGND.t126 1363.1
R1621 sky130_fd_sc_hs__and2_1_0.VGND VGND.t344 1363.1
R1622 sky130_fd_sc_hs__and2_1_0.VGND VGND.t70 1363.1
R1623 VGND.t48 VGND.t110 1363.1
R1624 VGND.t68 VGND.t335 1363.1
R1625 VGND.t236 VGND.t310 1344.44
R1626 VGND.t4 VGND.t136 1344.44
R1627 VGND.t248 VGND.t156 1344.44
R1628 VGND.t312 VGND.t11 1344.44
R1629 VGND.t161 VGND.t118 1344.44
R1630 VGND.t313 VGND.t316 1344.44
R1631 VGND.t237 VGND.t170 1344.44
R1632 sky130_fd_sc_hs__and2_1_0.VGND VGND.t64 1343.05
R1633 sky130_fd_sc_hs__and2_1_0.VGND VGND.t132 1343.05
R1634 VGND.t9 VGND.t94 1323.01
R1635 VGND.t188 VGND.t321 1323.01
R1636 sky130_fd_sc_hs__and2_1_0.VGND VGND.t122 1318.48
R1637 VGND.t240 VGND.t38 1293.52
R1638 VGND.t209 VGND.t291 1293.52
R1639 VGND.t302 VGND.t10 1293.52
R1640 VGND.t320 VGND.t201 1293.52
R1641 VGND.t206 VGND.t75 1293.52
R1642 VGND.t231 VGND.t299 1293.52
R1643 VGND.t141 VGND.t36 1293.52
R1644 VGND.t243 sky130_fd_sc_hs__and2_1_0.VGND 1282.92
R1645 VGND.t267 sky130_fd_sc_hs__and2_1_0.VGND 1282.92
R1646 VGND.t2 sky130_fd_sc_hs__and2_1_0.VGND 1282.92
R1647 VGND.t226 sky130_fd_sc_hs__and2_1_0.VGND 1282.92
R1648 VGND.t14 sky130_fd_sc_hs__and2_1_0.VGND 1282.92
R1649 VGND.t41 sky130_fd_sc_hs__and2_1_0.VGND 1282.92
R1650 sky130_fd_sc_hs__and2_1_0.VGND VGND.t323 1282.92
R1651 VGND.t233 sky130_fd_sc_hs__and2_1_0.VGND 1282.92
R1652 VGND.t3 sky130_fd_sc_hs__and2_1_0.VGND 1282.92
R1653 VGND.t300 VGND.t27 1272.89
R1654 VGND.t140 VGND.t58 1272.89
R1655 VGND.t114 VGND.t255 1262.96
R1656 VGND.t227 VGND.t249 1262.96
R1657 VGND.t92 VGND.t263 1262.96
R1658 VGND.t174 VGND.t253 1262.96
R1659 VGND.t124 VGND.t259 1262.96
R1660 VGND.t199 VGND.t251 1262.96
R1661 VGND.t325 VGND.t265 1262.96
R1662 VGND.t186 VGND.t257 1242.82
R1663 VGND.t224 VGND.t261 1242.82
R1664 VGND.t284 VGND.t331 1242.59
R1665 VGND.t268 VGND.t146 1242.59
R1666 VGND.t282 VGND.t318 1242.59
R1667 VGND.t272 VGND.t210 1242.59
R1668 VGND.t276 VGND.t193 1242.59
R1669 VGND.t280 VGND.t308 1242.59
R1670 VGND.t270 VGND.t182 1242.59
R1671 sky130_fd_sc_hs__and2_1_0.VGND VGND.t105 1222.78
R1672 sky130_fd_sc_hs__and2_1_0.VGND VGND.t159 1222.78
R1673 sky130_fd_sc_hs__and2_1_0.VGND VGND.t178 1222.78
R1674 VGND.t274 VGND.t164 1222.78
R1675 VGND.t278 VGND.t202 1222.78
R1676 sky130_fd_sc_hs__and2_1_0.VGND VGND.t204 1202.73
R1677 sky130_fd_sc_hs__and2_1_0.VGND VGND.t60 1202.73
R1678 sky130_fd_sc_hs__and2_1_0.VGND VGND.t56 1202.73
R1679 sky130_fd_sc_hs__and2_1_0.VGND VGND.t96 1202.73
R1680 sky130_fd_sc_hs__and2_1_0.VGND VGND.t333 1182.69
R1681 VGND.t105 VGND.t191 1162.64
R1682 VGND.t333 VGND.t238 1162.64
R1683 VGND.t204 VGND.t289 1162.64
R1684 VGND.t159 VGND.t148 1162.64
R1685 VGND.t60 VGND.t197 1162.64
R1686 VGND.t56 VGND.t314 1162.64
R1687 VGND.t178 VGND.t102 1162.64
R1688 sky130_fd_sc_hs__and2_1_0.VGND VGND.t23 1162.64
R1689 VGND.t96 VGND.t241 1162.64
R1690 sky130_fd_sc_hs__and2_1_0.VGND VGND.t120 1150.93
R1691 sky130_fd_sc_hs__and2_1_0.VGND VGND.t112 1150.93
R1692 sky130_fd_sc_hs__and2_1_0.VGND VGND.t128 1150.93
R1693 sky130_fd_sc_hs__and2_1_0.VGND VGND.t138 1150.93
R1694 sky130_fd_sc_hs__and2_1_0.VGND VGND.t207 1150.93
R1695 sky130_fd_sc_hs__and2_1_0.VGND VGND.t292 1150.93
R1696 sky130_fd_sc_hs__dfxtp_1_6.VNB VGND.t234 1150.93
R1697 VGND.t64 VGND.t286 1142.6
R1698 VGND.t191 VGND.t243 1142.6
R1699 VGND.t44 VGND.t232 1142.6
R1700 VGND.t238 VGND.t267 1142.6
R1701 VGND.t126 VGND.t296 1142.6
R1702 VGND.t289 VGND.t2 1142.6
R1703 VGND.t132 VGND.t307 1142.6
R1704 VGND.t148 VGND.t226 1142.6
R1705 VGND.t344 VGND.t158 1142.6
R1706 VGND.t197 VGND.t14 1142.6
R1707 VGND.t70 VGND.t13 1142.6
R1708 VGND.t314 VGND.t41 1142.6
R1709 VGND.t323 VGND.t72 1142.6
R1710 VGND.t102 VGND.t233 1142.6
R1711 VGND.t23 VGND.t104 1142.6
R1712 VGND.t241 VGND.t3 1142.6
R1713 sky130_fd_sc_hs__and2_1_0.VGND VGND.t176 1132.57
R1714 sky130_fd_sc_hs__and2_1_0.VGND VGND.t42 1132.57
R1715 VGND.t38 VGND.t195 1038.89
R1716 VGND.t291 VGND.t220 1038.89
R1717 VGND.t10 VGND.t287 1038.89
R1718 VGND.t201 VGND.t25 1038.89
R1719 VGND.t75 VGND.t81 1038.89
R1720 VGND.t299 VGND.t142 1038.89
R1721 VGND.t36 VGND.t216 1038.89
R1722 VGND.t120 VGND.t284 1028.7
R1723 VGND.t112 VGND.t268 1028.7
R1724 VGND.t128 VGND.t282 1028.7
R1725 VGND.t138 VGND.t272 1028.7
R1726 VGND.t207 VGND.t276 1028.7
R1727 VGND.t292 VGND.t280 1028.7
R1728 VGND.t234 VGND.t270 1028.7
R1729 VGND.t244 VGND.t130 1022.32
R1730 VGND.t180 VGND.t340 1022.32
R1731 VGND.t218 VGND.t154 1022.32
R1732 VGND.t297 VGND.t229 1022.32
R1733 VGND.t0 VGND.t134 1022.32
R1734 VGND.t66 VGND.t88 1022.32
R1735 VGND.t46 VGND.t19 1022.32
R1736 VGND.t15 VGND.t305 1022.32
R1737 VGND.t27 VGND.t48 1022.32
R1738 VGND.t58 VGND.t68 1022.32
R1739 VGND.t176 VGND.t274 1012.3
R1740 VGND.t42 VGND.t278 1012.3
R1741 VGND.t255 sky130_fd_sc_hs__and2_1_0.VGND 1008.33
R1742 VGND.t327 VGND.t212 1008.33
R1743 sky130_fd_sc_hs__and2_1_0.VGND VGND.t327 1008.33
R1744 VGND.t249 sky130_fd_sc_hs__and2_1_0.VGND 1008.33
R1745 VGND.t329 VGND.t184 1008.33
R1746 sky130_fd_sc_hs__and2_1_0.VGND VGND.t329 1008.33
R1747 VGND.t263 sky130_fd_sc_hs__and2_1_0.VGND 1008.33
R1748 VGND.t77 VGND.t107 1008.33
R1749 sky130_fd_sc_hs__and2_1_0.VGND VGND.t77 1008.33
R1750 VGND.t253 sky130_fd_sc_hs__and2_1_0.VGND 1008.33
R1751 VGND.t32 VGND.t172 1008.33
R1752 sky130_fd_sc_hs__and2_1_0.VGND VGND.t32 1008.33
R1753 VGND.t259 sky130_fd_sc_hs__and2_1_0.VGND 1008.33
R1754 VGND.t52 VGND.t342 1008.33
R1755 sky130_fd_sc_hs__and2_1_0.VGND VGND.t52 1008.33
R1756 VGND.t251 sky130_fd_sc_hs__and2_1_0.VGND 1008.33
R1757 VGND.t222 VGND.t73 1008.33
R1758 sky130_fd_sc_hs__and2_1_0.VGND VGND.t222 1008.33
R1759 VGND.t265 sky130_fd_sc_hs__dfxtp_1_6.VNB 1008.33
R1760 VGND.t257 sky130_fd_sc_hs__and2_1_0.VGND 992.255
R1761 VGND.t50 VGND.t166 992.255
R1762 sky130_fd_sc_hs__and2_1_0.VGND VGND.t50 992.255
R1763 VGND.t261 sky130_fd_sc_hs__and2_1_0.VGND 992.255
R1764 VGND.t30 VGND.t7 992.255
R1765 VGND.t59 VGND.t236 967.593
R1766 VGND.t37 VGND.t4 967.593
R1767 VGND.t40 VGND.t248 967.593
R1768 VGND.t109 VGND.t312 967.593
R1769 VGND.t76 VGND.t161 967.593
R1770 VGND.t87 VGND.t313 967.593
R1771 VGND.t339 VGND.t237 967.593
R1772 VGND.t39 VGND.t9 952.164
R1773 VGND.t301 VGND.t188 952.164
R1774 VGND.n233 VGND.n232 861.96
R1775 VGND.t189 VGND.t240 845.37
R1776 VGND.t98 VGND.t209 845.37
R1777 VGND.t303 VGND.t302 845.37
R1778 VGND.t150 VGND.t320 845.37
R1779 VGND.t54 VGND.t206 845.37
R1780 VGND.t168 VGND.t231 845.37
R1781 VGND.t17 VGND.t300 831.891
R1782 VGND.t90 VGND.t140 831.891
R1783 VGND.t286 VGND.t244 781.778
R1784 VGND.t232 VGND.t180 781.778
R1785 VGND.t296 VGND.t218 781.778
R1786 VGND.t307 VGND.t297 781.778
R1787 VGND.t158 VGND.t0 781.778
R1788 VGND.t13 VGND.t66 781.778
R1789 VGND.t72 VGND.t46 781.778
R1790 VGND.t104 VGND.t15 781.778
R1791 VGND.t5 VGND.t59 733.333
R1792 VGND.t85 VGND.t37 733.333
R1793 VGND.t34 VGND.t40 733.333
R1794 VGND.t116 VGND.t109 733.333
R1795 VGND.t79 VGND.t76 733.333
R1796 VGND.t162 VGND.t87 733.333
R1797 VGND.t21 VGND.t339 733.333
R1798 VGND.t110 VGND.t39 721.64
R1799 VGND.t335 VGND.t301 721.64
R1800 VGND.t337 VGND.t144 700.885
R1801 VGND.n486 VGND.n484 611.778
R1802 VGND.n232 VGND.n231 611.778
R1803 VGND.n483 VGND.n482 611.778
R1804 VGND.n484 sky130_fd_sc_hs__and2_1_0.VGND 481.094
R1805 VGND.n483 sky130_fd_sc_hs__and2_1_0.VGND 468.519
R1806 VGND.t122 VGND.t337 350.442
R1807 VGND.n464 VGND.t311 315.938
R1808 VGND.n123 VGND.t137 315.938
R1809 VGND.n394 VGND.t157 315.938
R1810 VGND.n357 VGND.t12 315.938
R1811 VGND.n161 VGND.t119 315.938
R1812 VGND.n288 VGND.t317 315.938
R1813 VGND.n251 VGND.t171 315.938
R1814 VGND.n649 VGND.t95 315.938
R1815 VGND.n212 VGND.t322 315.938
R1816 VGND.n233 VGND.t141 295.37
R1817 VGND.n101 VGND.t65 274.164
R1818 VGND.n93 VGND.t45 274.164
R1819 VGND.n82 VGND.t127 274.164
R1820 VGND.n71 VGND.t133 274.164
R1821 VGND.n60 VGND.t345 274.164
R1822 VGND.n49 VGND.t71 274.164
R1823 VGND.n38 VGND.t324 274.164
R1824 VGND.n27 VGND.t24 274.164
R1825 VGND.n449 VGND.t190 257.195
R1826 VGND.n413 VGND.t99 257.195
R1827 VGND.n143 VGND.t304 257.195
R1828 VGND.n343 VGND.t151 257.195
R1829 VGND.n307 VGND.t55 257.195
R1830 VGND.n181 VGND.t169 257.195
R1831 VGND.n237 VGND.t145 257.195
R1832 VGND.n8 VGND.t18 257.195
R1833 VGND.n225 VGND.t91 257.195
R1834 VGND.n109 VGND.t121 237.726
R1835 VGND.n436 VGND.t113 237.726
R1836 VGND.n401 VGND.t129 237.726
R1837 VGND.n147 VGND.t139 237.726
R1838 VGND.n330 VGND.t208 237.726
R1839 VGND.n295 VGND.t293 237.726
R1840 VGND.n185 VGND.t235 237.726
R1841 VGND.n642 VGND.t177 237.726
R1842 VGND.n674 VGND.t43 237.726
R1843 VGND.n503 VGND.n99 217.776
R1844 VGND.n90 VGND.n89 217.776
R1845 VGND.n79 VGND.n78 217.776
R1846 VGND.n68 VGND.n67 217.776
R1847 VGND.n57 VGND.n56 217.776
R1848 VGND.n46 VGND.n45 217.776
R1849 VGND.n35 VGND.n34 217.776
R1850 VGND.n24 VGND.n23 217.776
R1851 VGND.n470 VGND.n469 214.185
R1852 VGND.n432 VGND.n431 214.185
R1853 VGND.n136 VGND.n135 214.185
R1854 VGND.n363 VGND.n362 214.185
R1855 VGND.n326 VGND.n325 214.185
R1856 VGND.n174 VGND.n173 214.185
R1857 VGND.n257 VGND.n256 214.185
R1858 VGND.n16 VGND.n15 214.185
R1859 VGND.n207 VGND.n206 214.185
R1860 VGND.n458 VGND.n457 211.452
R1861 VGND.n126 VGND.n125 211.452
R1862 VGND.n388 VGND.n141 211.452
R1863 VGND.n351 VGND.n350 211.452
R1864 VGND.n164 VGND.n163 211.452
R1865 VGND.n282 VGND.n179 211.452
R1866 VGND.n245 VGND.n244 211.452
R1867 VGND.n655 VGND.n12 211.452
R1868 VGND.n218 VGND.n201 211.452
R1869 VGND.n118 VGND.n117 205.928
R1870 VGND.n411 VGND.n131 205.928
R1871 VGND.n377 VGND.n376 205.928
R1872 VGND.n156 VGND.n155 205.928
R1873 VGND.n305 VGND.n169 205.928
R1874 VGND.n271 VGND.n270 205.928
R1875 VGND.n194 VGND.n193 205.928
R1876 VGND.n666 VGND.n7 205.928
R1877 VGND.n227 VGND.n197 205.928
R1878 VGND.t144 VGND.n233 191.15
R1879 VGND.n487 VGND.t247 156.095
R1880 VGND.n97 VGND.t215 156.095
R1881 VGND.n528 VGND.t295 156.095
R1882 VGND.n546 VGND.t153 156.095
R1883 VGND.n564 VGND.t63 156.095
R1884 VGND.n582 VGND.t29 156.095
R1885 VGND.n600 VGND.t101 156.095
R1886 VGND.n618 VGND.t84 156.095
R1887 VGND.n104 VGND.n103 123.984
R1888 VGND.n95 VGND.n94 123.984
R1889 VGND.n84 VGND.n83 123.984
R1890 VGND.n73 VGND.n72 123.984
R1891 VGND.n62 VGND.n61 123.984
R1892 VGND.n51 VGND.n50 123.984
R1893 VGND.n40 VGND.n39 123.984
R1894 VGND.n29 VGND.n28 123.984
R1895 VGND.n477 VGND.n476 121.07
R1896 VGND.n439 VGND.n438 121.07
R1897 VGND.n405 VGND.n134 121.07
R1898 VGND.n370 VGND.n369 121.07
R1899 VGND.n333 VGND.n332 121.07
R1900 VGND.n299 VGND.n172 121.07
R1901 VGND.n264 VGND.n263 121.07
R1902 VGND.n19 VGND.n18 121.07
R1903 VGND.n672 VGND.n3 121.07
R1904 VGND.n476 VGND.t332 69.1152
R1905 VGND.n438 VGND.t147 69.1152
R1906 VGND.n134 VGND.t319 69.1152
R1907 VGND.n369 VGND.t211 69.1152
R1908 VGND.n332 VGND.t194 69.1152
R1909 VGND.n172 VGND.t309 69.1152
R1910 VGND.n263 VGND.t183 69.1152
R1911 VGND.n18 VGND.t165 69.1152
R1912 VGND.n3 VGND.t203 69.1152
R1913 VGND.n457 VGND.t196 67.6369
R1914 VGND.n125 VGND.t221 67.6369
R1915 VGND.n141 VGND.t288 67.6369
R1916 VGND.n350 VGND.t26 67.6369
R1917 VGND.n163 VGND.t82 67.6369
R1918 VGND.n179 VGND.t143 67.6369
R1919 VGND.n244 VGND.t217 67.6369
R1920 VGND.n12 VGND.t49 67.6369
R1921 VGND.n201 VGND.t69 67.6369
R1922 VGND.n469 VGND.t115 53.514
R1923 VGND.n431 VGND.t228 53.514
R1924 VGND.n135 VGND.t93 53.514
R1925 VGND.n362 VGND.t175 53.514
R1926 VGND.n325 VGND.t125 53.514
R1927 VGND.n173 VGND.t200 53.514
R1928 VGND.n256 VGND.t326 53.514
R1929 VGND.n15 VGND.t187 53.514
R1930 VGND.n206 VGND.t225 53.514
R1931 VGND.n457 VGND.t6 53.0654
R1932 VGND.n125 VGND.t86 53.0654
R1933 VGND.n141 VGND.t35 53.0654
R1934 VGND.n350 VGND.t117 53.0654
R1935 VGND.n163 VGND.t80 53.0654
R1936 VGND.n179 VGND.t163 53.0654
R1937 VGND.n244 VGND.t22 53.0654
R1938 VGND.n12 VGND.t111 53.0654
R1939 VGND.n201 VGND.t336 53.0654
R1940 VGND.n103 VGND.t131 47.2956
R1941 VGND.n94 VGND.t341 47.2956
R1942 VGND.n83 VGND.t155 47.2956
R1943 VGND.n72 VGND.t230 47.2956
R1944 VGND.n61 VGND.t135 47.2956
R1945 VGND.n50 VGND.t89 47.2956
R1946 VGND.n39 VGND.t20 47.2956
R1947 VGND.n28 VGND.t306 47.2956
R1948 VGND.n99 VGND.t192 41.2505
R1949 VGND.n89 VGND.t239 41.2505
R1950 VGND.n78 VGND.t290 41.2505
R1951 VGND.n67 VGND.t149 41.2505
R1952 VGND.n56 VGND.t198 41.2505
R1953 VGND.n45 VGND.t315 41.2505
R1954 VGND.n34 VGND.t103 41.2505
R1955 VGND.n23 VGND.t242 41.2505
R1956 VGND.n478 VGND.n107 36.1417
R1957 VGND.n468 VGND.n111 36.1417
R1958 VGND.n463 VGND.n462 36.1417
R1959 VGND.n462 VGND.n113 36.1417
R1960 VGND.n456 VGND.n455 36.1417
R1961 VGND.n455 VGND.n115 36.1417
R1962 VGND.n450 VGND.n115 36.1417
R1963 VGND.n444 VGND.n443 36.1417
R1964 VGND.n443 VGND.n119 36.1417
R1965 VGND.n430 VGND.n429 36.1417
R1966 VGND.n425 VGND.n424 36.1417
R1967 VGND.n424 VGND.n423 36.1417
R1968 VGND.n419 VGND.n418 36.1417
R1969 VGND.n418 VGND.n417 36.1417
R1970 VGND.n417 VGND.n128 36.1417
R1971 VGND.n407 VGND.n130 36.1417
R1972 VGND.n407 VGND.n406 36.1417
R1973 VGND.n396 VGND.n395 36.1417
R1974 VGND.n390 VGND.n138 36.1417
R1975 VGND.n390 VGND.n389 36.1417
R1976 VGND.n384 VGND.n140 36.1417
R1977 VGND.n384 VGND.n383 36.1417
R1978 VGND.n383 VGND.n382 36.1417
R1979 VGND.n375 VGND.n145 36.1417
R1980 VGND.n371 VGND.n145 36.1417
R1981 VGND.n361 VGND.n149 36.1417
R1982 VGND.n356 VGND.n355 36.1417
R1983 VGND.n355 VGND.n151 36.1417
R1984 VGND.n349 VGND.n348 36.1417
R1985 VGND.n348 VGND.n153 36.1417
R1986 VGND.n344 VGND.n153 36.1417
R1987 VGND.n338 VGND.n337 36.1417
R1988 VGND.n337 VGND.n157 36.1417
R1989 VGND.n324 VGND.n323 36.1417
R1990 VGND.n319 VGND.n318 36.1417
R1991 VGND.n318 VGND.n317 36.1417
R1992 VGND.n313 VGND.n312 36.1417
R1993 VGND.n312 VGND.n311 36.1417
R1994 VGND.n311 VGND.n166 36.1417
R1995 VGND.n301 VGND.n168 36.1417
R1996 VGND.n301 VGND.n300 36.1417
R1997 VGND.n290 VGND.n289 36.1417
R1998 VGND.n284 VGND.n176 36.1417
R1999 VGND.n284 VGND.n283 36.1417
R2000 VGND.n278 VGND.n178 36.1417
R2001 VGND.n278 VGND.n277 36.1417
R2002 VGND.n277 VGND.n276 36.1417
R2003 VGND.n269 VGND.n183 36.1417
R2004 VGND.n265 VGND.n183 36.1417
R2005 VGND.n255 VGND.n187 36.1417
R2006 VGND.n250 VGND.n249 36.1417
R2007 VGND.n249 VGND.n189 36.1417
R2008 VGND.n243 VGND.n242 36.1417
R2009 VGND.n242 VGND.n191 36.1417
R2010 VGND.n238 VGND.n191 36.1417
R2011 VGND.n489 VGND.n488 36.1417
R2012 VGND.n493 VGND.n492 36.1417
R2013 VGND.n494 VGND.n493 36.1417
R2014 VGND.n498 VGND.n100 36.1417
R2015 VGND.n502 VGND.n100 36.1417
R2016 VGND.n505 VGND.n504 36.1417
R2017 VGND.n511 VGND.n510 36.1417
R2018 VGND.n516 VGND.n515 36.1417
R2019 VGND.n517 VGND.n516 36.1417
R2020 VGND.n521 VGND.n91 36.1417
R2021 VGND.n522 VGND.n521 36.1417
R2022 VGND.n523 VGND.n522 36.1417
R2023 VGND.n527 VGND.n87 36.1417
R2024 VGND.n530 VGND.n529 36.1417
R2025 VGND.n534 VGND.n533 36.1417
R2026 VGND.n535 VGND.n534 36.1417
R2027 VGND.n539 VGND.n80 36.1417
R2028 VGND.n540 VGND.n539 36.1417
R2029 VGND.n541 VGND.n540 36.1417
R2030 VGND.n545 VGND.n76 36.1417
R2031 VGND.n548 VGND.n547 36.1417
R2032 VGND.n552 VGND.n551 36.1417
R2033 VGND.n553 VGND.n552 36.1417
R2034 VGND.n558 VGND.n557 36.1417
R2035 VGND.n559 VGND.n558 36.1417
R2036 VGND.n563 VGND.n65 36.1417
R2037 VGND.n566 VGND.n565 36.1417
R2038 VGND.n570 VGND.n569 36.1417
R2039 VGND.n571 VGND.n570 36.1417
R2040 VGND.n575 VGND.n58 36.1417
R2041 VGND.n576 VGND.n575 36.1417
R2042 VGND.n577 VGND.n576 36.1417
R2043 VGND.n581 VGND.n54 36.1417
R2044 VGND.n584 VGND.n583 36.1417
R2045 VGND.n588 VGND.n587 36.1417
R2046 VGND.n589 VGND.n588 36.1417
R2047 VGND.n593 VGND.n47 36.1417
R2048 VGND.n594 VGND.n593 36.1417
R2049 VGND.n595 VGND.n594 36.1417
R2050 VGND.n599 VGND.n43 36.1417
R2051 VGND.n602 VGND.n601 36.1417
R2052 VGND.n606 VGND.n605 36.1417
R2053 VGND.n607 VGND.n606 36.1417
R2054 VGND.n612 VGND.n611 36.1417
R2055 VGND.n613 VGND.n612 36.1417
R2056 VGND.n617 VGND.n32 36.1417
R2057 VGND.n620 VGND.n619 36.1417
R2058 VGND.n624 VGND.n623 36.1417
R2059 VGND.n625 VGND.n624 36.1417
R2060 VGND.n630 VGND.n629 36.1417
R2061 VGND.n631 VGND.n630 36.1417
R2062 VGND.n635 VGND.n21 36.1417
R2063 VGND.n637 VGND.n636 36.1417
R2064 VGND.n648 VGND.n647 36.1417
R2065 VGND.n653 VGND.n13 36.1417
R2066 VGND.n654 VGND.n653 36.1417
R2067 VGND.n659 VGND.n10 36.1417
R2068 VGND.n660 VGND.n659 36.1417
R2069 VGND.n661 VGND.n660 36.1417
R2070 VGND.n667 VGND.n5 36.1417
R2071 VGND.n671 VGND.n5 36.1417
R2072 VGND.n211 VGND.n205 36.1417
R2073 VGND.n213 VGND.n203 36.1417
R2074 VGND.n217 VGND.n203 36.1417
R2075 VGND.n220 VGND.n219 36.1417
R2076 VGND.n220 VGND.n199 36.1417
R2077 VGND.n224 VGND.n199 36.1417
R2078 VGND.n458 VGND.n113 35.3887
R2079 VGND.n423 VGND.n126 35.3887
R2080 VGND.n389 VGND.n388 35.3887
R2081 VGND.n351 VGND.n151 35.3887
R2082 VGND.n317 VGND.n164 35.3887
R2083 VGND.n283 VGND.n282 35.3887
R2084 VGND.n245 VGND.n189 35.3887
R2085 VGND.n498 VGND.n497 35.3887
R2086 VGND.n557 VGND.n69 35.3887
R2087 VGND.n636 VGND.n635 35.3887
R2088 VGND.n655 VGND.n654 35.3887
R2089 VGND.n218 VGND.n217 35.3887
R2090 VGND.n611 VGND.n36 33.1299
R2091 VGND.n488 VGND.n487 32.0005
R2092 VGND.n510 VGND.n97 32.0005
R2093 VGND.n529 VGND.n528 32.0005
R2094 VGND.n547 VGND.n546 32.0005
R2095 VGND.n565 VGND.n564 32.0005
R2096 VGND.n583 VGND.n582 32.0005
R2097 VGND.n601 VGND.n600 32.0005
R2098 VGND.n619 VGND.n618 32.0005
R2099 VGND.n117 VGND.t213 31.8755
R2100 VGND.n131 VGND.t185 31.8755
R2101 VGND.n376 VGND.t108 31.8755
R2102 VGND.n155 VGND.t173 31.8755
R2103 VGND.n169 VGND.t343 31.8755
R2104 VGND.n270 VGND.t74 31.8755
R2105 VGND.n193 VGND.t338 31.8755
R2106 VGND.n7 VGND.t167 31.8755
R2107 VGND.n197 VGND.t8 31.8755
R2108 VGND.n505 VGND.n97 31.2476
R2109 VGND.n564 VGND.n563 31.2476
R2110 VGND.n618 VGND.n617 31.2476
R2111 VGND.n471 VGND.n109 30.8711
R2112 VGND.n436 VGND.n121 30.8711
R2113 VGND.n401 VGND.n400 30.8711
R2114 VGND.n364 VGND.n147 30.8711
R2115 VGND.n330 VGND.n159 30.8711
R2116 VGND.n295 VGND.n294 30.8711
R2117 VGND.n258 VGND.n185 30.8711
R2118 VGND.n643 VGND.n642 30.8711
R2119 VGND.n674 VGND.n2 30.8711
R2120 VGND.n470 VGND.n468 30.4946
R2121 VGND.n432 VGND.n430 30.4946
R2122 VGND.n396 VGND.n136 30.4946
R2123 VGND.n363 VGND.n361 30.4946
R2124 VGND.n326 VGND.n324 30.4946
R2125 VGND.n290 VGND.n174 30.4946
R2126 VGND.n257 VGND.n255 30.4946
R2127 VGND.n546 VGND.n545 30.4946
R2128 VGND.n582 VGND.n581 30.4946
R2129 VGND.n600 VGND.n599 30.4946
R2130 VGND.n647 VGND.n16 30.4946
R2131 VGND.n207 VGND.n205 30.4946
R2132 VGND.n99 VGND.t106 30.2643
R2133 VGND.n89 VGND.t334 30.2643
R2134 VGND.n78 VGND.t205 30.2643
R2135 VGND.n67 VGND.t160 30.2643
R2136 VGND.n56 VGND.t61 30.2643
R2137 VGND.n45 VGND.t57 30.2643
R2138 VGND.n34 VGND.t179 30.2643
R2139 VGND.n23 VGND.t97 30.2643
R2140 VGND.n477 VGND.n475 30.1181
R2141 VGND.n449 VGND.n448 30.1181
R2142 VGND.n439 VGND.n437 30.1181
R2143 VGND.n413 VGND.n412 30.1181
R2144 VGND.n405 VGND.n133 30.1181
R2145 VGND.n378 VGND.n143 30.1181
R2146 VGND.n370 VGND.n368 30.1181
R2147 VGND.n343 VGND.n342 30.1181
R2148 VGND.n333 VGND.n331 30.1181
R2149 VGND.n307 VGND.n306 30.1181
R2150 VGND.n299 VGND.n171 30.1181
R2151 VGND.n272 VGND.n181 30.1181
R2152 VGND.n264 VGND.n262 30.1181
R2153 VGND.n237 VGND.n236 30.1181
R2154 VGND.n641 VGND.n19 30.1181
R2155 VGND.n665 VGND.n8 30.1181
R2156 VGND.n673 VGND.n672 30.1181
R2157 VGND.n226 VGND.n225 30.1181
R2158 VGND.n528 VGND.n527 29.7417
R2159 VGND.n117 VGND.t328 29.2236
R2160 VGND.n131 VGND.t330 29.2236
R2161 VGND.n376 VGND.t78 29.2236
R2162 VGND.n155 VGND.t33 29.2236
R2163 VGND.n169 VGND.t53 29.2236
R2164 VGND.n270 VGND.t223 29.2236
R2165 VGND.n193 VGND.t123 29.2236
R2166 VGND.n7 VGND.t51 29.2236
R2167 VGND.n197 VGND.t31 29.2236
R2168 VGND.n444 VGND.n118 28.9887
R2169 VGND.n411 VGND.n130 28.9887
R2170 VGND.n377 VGND.n375 28.9887
R2171 VGND.n338 VGND.n156 28.9887
R2172 VGND.n305 VGND.n168 28.9887
R2173 VGND.n271 VGND.n269 28.9887
R2174 VGND.n667 VGND.n666 28.9887
R2175 VGND.n227 VGND.n195 28.9887
R2176 VGND.n629 VGND.n25 28.6123
R2177 VGND.n231 VGND.n195 24.8476
R2178 VGND.n464 VGND.n463 24.4711
R2179 VGND.n425 VGND.n123 24.4711
R2180 VGND.n394 VGND.n138 24.4711
R2181 VGND.n357 VGND.n356 24.4711
R2182 VGND.n319 VGND.n161 24.4711
R2183 VGND.n288 VGND.n176 24.4711
R2184 VGND.n251 VGND.n250 24.4711
R2185 VGND.n649 VGND.n13 24.4711
R2186 VGND.n213 VGND.n212 24.4711
R2187 VGND.n482 VGND.n107 24.0946
R2188 VGND.n471 VGND.n470 22.9652
R2189 VGND.n464 VGND.n111 22.9652
R2190 VGND.n432 VGND.n121 22.9652
R2191 VGND.n429 VGND.n123 22.9652
R2192 VGND.n400 VGND.n136 22.9652
R2193 VGND.n395 VGND.n394 22.9652
R2194 VGND.n364 VGND.n363 22.9652
R2195 VGND.n357 VGND.n149 22.9652
R2196 VGND.n326 VGND.n159 22.9652
R2197 VGND.n323 VGND.n161 22.9652
R2198 VGND.n294 VGND.n174 22.9652
R2199 VGND.n289 VGND.n288 22.9652
R2200 VGND.n258 VGND.n257 22.9652
R2201 VGND.n251 VGND.n187 22.9652
R2202 VGND.n643 VGND.n16 22.9652
R2203 VGND.n649 VGND.n648 22.9652
R2204 VGND.n207 VGND.n2 22.9652
R2205 VGND.n212 VGND.n211 22.9652
R2206 VGND.n469 VGND.t256 22.7032
R2207 VGND.n431 VGND.t250 22.7032
R2208 VGND.n135 VGND.t264 22.7032
R2209 VGND.n362 VGND.t254 22.7032
R2210 VGND.n325 VGND.t260 22.7032
R2211 VGND.n173 VGND.t252 22.7032
R2212 VGND.n256 VGND.t266 22.7032
R2213 VGND.n15 VGND.t258 22.7032
R2214 VGND.n206 VGND.t262 22.7032
R2215 VGND.n103 VGND.t245 21.9347
R2216 VGND.n94 VGND.t181 21.9347
R2217 VGND.n83 VGND.t219 21.9347
R2218 VGND.n72 VGND.t298 21.9347
R2219 VGND.n61 VGND.t1 21.9347
R2220 VGND.n50 VGND.t67 21.9347
R2221 VGND.n39 VGND.t47 21.9347
R2222 VGND.n28 VGND.t16 21.9347
R2223 VGND.n476 VGND.t285 21.9332
R2224 VGND.n438 VGND.t269 21.9332
R2225 VGND.n134 VGND.t283 21.9332
R2226 VGND.n369 VGND.t273 21.9332
R2227 VGND.n332 VGND.t277 21.9332
R2228 VGND.n172 VGND.t281 21.9332
R2229 VGND.n263 VGND.t271 21.9332
R2230 VGND.n18 VGND.t275 21.9332
R2231 VGND.n3 VGND.t279 21.9332
R2232 VGND.n475 VGND.n109 20.7064
R2233 VGND.n437 VGND.n436 20.7064
R2234 VGND.n401 VGND.n133 20.7064
R2235 VGND.n368 VGND.n147 20.7064
R2236 VGND.n331 VGND.n330 20.7064
R2237 VGND.n295 VGND.n171 20.7064
R2238 VGND.n262 VGND.n185 20.7064
R2239 VGND.n642 VGND.n641 20.7064
R2240 VGND.n674 VGND.n673 20.7064
R2241 VGND.n487 VGND.n486 19.9534
R2242 VGND.n448 VGND.n118 19.577
R2243 VGND.n412 VGND.n411 19.577
R2244 VGND.n378 VGND.n377 19.577
R2245 VGND.n342 VGND.n156 19.577
R2246 VGND.n306 VGND.n305 19.577
R2247 VGND.n272 VGND.n271 19.577
R2248 VGND.n236 VGND.n194 19.577
R2249 VGND.n666 VGND.n665 19.577
R2250 VGND.n227 VGND.n226 19.577
R2251 VGND.n458 VGND.n456 18.0711
R2252 VGND.n419 VGND.n126 18.0711
R2253 VGND.n388 VGND.n140 18.0711
R2254 VGND.n351 VGND.n349 18.0711
R2255 VGND.n313 VGND.n164 18.0711
R2256 VGND.n282 VGND.n178 18.0711
R2257 VGND.n245 VGND.n243 18.0711
R2258 VGND.n655 VGND.n10 18.0711
R2259 VGND.n219 VGND.n218 18.0711
R2260 VGND.n478 VGND.n477 17.3181
R2261 VGND.n450 VGND.n449 17.3181
R2262 VGND.n439 VGND.n119 17.3181
R2263 VGND.n413 VGND.n128 17.3181
R2264 VGND.n406 VGND.n405 17.3181
R2265 VGND.n382 VGND.n143 17.3181
R2266 VGND.n371 VGND.n370 17.3181
R2267 VGND.n344 VGND.n343 17.3181
R2268 VGND.n333 VGND.n157 17.3181
R2269 VGND.n307 VGND.n166 17.3181
R2270 VGND.n300 VGND.n299 17.3181
R2271 VGND.n276 VGND.n181 17.3181
R2272 VGND.n265 VGND.n264 17.3181
R2273 VGND.n238 VGND.n237 17.3181
R2274 VGND.n637 VGND.n19 17.3181
R2275 VGND.n661 VGND.n8 17.3181
R2276 VGND.n672 VGND.n671 17.3181
R2277 VGND.n225 VGND.n224 17.3181
R2278 VGND.n453 VGND.n96 10.5583
R2279 VGND.n489 VGND.n104 10.5417
R2280 VGND.n503 VGND.n502 10.5417
R2281 VGND.n511 VGND.n95 10.5417
R2282 VGND.n523 VGND.n90 10.5417
R2283 VGND.n530 VGND.n84 10.5417
R2284 VGND.n541 VGND.n79 10.5417
R2285 VGND.n548 VGND.n73 10.5417
R2286 VGND.n559 VGND.n68 10.5417
R2287 VGND.n566 VGND.n62 10.5417
R2288 VGND.n577 VGND.n57 10.5417
R2289 VGND.n584 VGND.n51 10.5417
R2290 VGND.n595 VGND.n46 10.5417
R2291 VGND.n602 VGND.n40 10.5417
R2292 VGND.n613 VGND.n35 10.5417
R2293 VGND.n620 VGND.n29 10.5417
R2294 VGND.n631 VGND.n24 10.5417
R2295 VGND.n231 sky130_fd_sc_hs__and2_1_0.VGND 9.36172
R2296 VGND.n515 VGND.n514 9.3005
R2297 VGND.n516 VGND.n92 9.3005
R2298 VGND.n518 VGND.n517 9.3005
R2299 VGND.n519 VGND.n91 9.3005
R2300 VGND.n521 VGND.n520 9.3005
R2301 VGND.n522 VGND.n88 9.3005
R2302 VGND.n524 VGND.n523 9.3005
R2303 VGND.n525 VGND.n87 9.3005
R2304 VGND.n527 VGND.n526 9.3005
R2305 VGND.n529 VGND.n85 9.3005
R2306 VGND.n531 VGND.n530 9.3005
R2307 VGND.n533 VGND.n532 9.3005
R2308 VGND.n534 VGND.n81 9.3005
R2309 VGND.n536 VGND.n535 9.3005
R2310 VGND.n537 VGND.n80 9.3005
R2311 VGND.n539 VGND.n538 9.3005
R2312 VGND.n540 VGND.n77 9.3005
R2313 VGND.n542 VGND.n541 9.3005
R2314 VGND.n543 VGND.n76 9.3005
R2315 VGND.n545 VGND.n544 9.3005
R2316 VGND.n547 VGND.n74 9.3005
R2317 VGND.n549 VGND.n548 9.3005
R2318 VGND.n551 VGND.n550 9.3005
R2319 VGND.n552 VGND.n70 9.3005
R2320 VGND.n554 VGND.n553 9.3005
R2321 VGND.n555 VGND.n69 9.3005
R2322 VGND.n557 VGND.n556 9.3005
R2323 VGND.n558 VGND.n66 9.3005
R2324 VGND.n560 VGND.n559 9.3005
R2325 VGND.n561 VGND.n65 9.3005
R2326 VGND.n563 VGND.n562 9.3005
R2327 VGND.n565 VGND.n63 9.3005
R2328 VGND.n567 VGND.n566 9.3005
R2329 VGND.n569 VGND.n568 9.3005
R2330 VGND.n570 VGND.n59 9.3005
R2331 VGND.n572 VGND.n571 9.3005
R2332 VGND.n573 VGND.n58 9.3005
R2333 VGND.n575 VGND.n574 9.3005
R2334 VGND.n576 VGND.n55 9.3005
R2335 VGND.n578 VGND.n577 9.3005
R2336 VGND.n579 VGND.n54 9.3005
R2337 VGND.n581 VGND.n580 9.3005
R2338 VGND.n583 VGND.n52 9.3005
R2339 VGND.n585 VGND.n584 9.3005
R2340 VGND.n587 VGND.n586 9.3005
R2341 VGND.n588 VGND.n48 9.3005
R2342 VGND.n590 VGND.n589 9.3005
R2343 VGND.n591 VGND.n47 9.3005
R2344 VGND.n593 VGND.n592 9.3005
R2345 VGND.n594 VGND.n44 9.3005
R2346 VGND.n596 VGND.n595 9.3005
R2347 VGND.n597 VGND.n43 9.3005
R2348 VGND.n599 VGND.n598 9.3005
R2349 VGND.n601 VGND.n41 9.3005
R2350 VGND.n603 VGND.n602 9.3005
R2351 VGND.n605 VGND.n604 9.3005
R2352 VGND.n606 VGND.n37 9.3005
R2353 VGND.n608 VGND.n607 9.3005
R2354 VGND.n609 VGND.n36 9.3005
R2355 VGND.n611 VGND.n610 9.3005
R2356 VGND.n612 VGND.n33 9.3005
R2357 VGND.n614 VGND.n613 9.3005
R2358 VGND.n615 VGND.n32 9.3005
R2359 VGND.n617 VGND.n616 9.3005
R2360 VGND.n619 VGND.n30 9.3005
R2361 VGND.n621 VGND.n620 9.3005
R2362 VGND.n623 VGND.n622 9.3005
R2363 VGND.n624 VGND.n26 9.3005
R2364 VGND.n626 VGND.n625 9.3005
R2365 VGND.n627 VGND.n25 9.3005
R2366 VGND.n629 VGND.n628 9.3005
R2367 VGND.n630 VGND.n22 9.3005
R2368 VGND.n632 VGND.n631 9.3005
R2369 VGND.n633 VGND.n21 9.3005
R2370 VGND.n635 VGND.n634 9.3005
R2371 VGND.n636 VGND.n20 9.3005
R2372 VGND.n638 VGND.n637 9.3005
R2373 VGND.n639 VGND.n19 9.3005
R2374 VGND.n641 VGND.n640 9.3005
R2375 VGND.n642 VGND.n17 9.3005
R2376 VGND.n644 VGND.n643 9.3005
R2377 VGND.n645 VGND.n16 9.3005
R2378 VGND.n647 VGND.n646 9.3005
R2379 VGND.n648 VGND.n14 9.3005
R2380 VGND.n650 VGND.n649 9.3005
R2381 VGND.n651 VGND.n13 9.3005
R2382 VGND.n653 VGND.n652 9.3005
R2383 VGND.n654 VGND.n11 9.3005
R2384 VGND.n656 VGND.n655 9.3005
R2385 VGND.n657 VGND.n10 9.3005
R2386 VGND.n659 VGND.n658 9.3005
R2387 VGND.n660 VGND.n9 9.3005
R2388 VGND.n662 VGND.n661 9.3005
R2389 VGND.n663 VGND.n8 9.3005
R2390 VGND.n665 VGND.n664 9.3005
R2391 VGND.n666 VGND.n6 9.3005
R2392 VGND.n668 VGND.n667 9.3005
R2393 VGND.n669 VGND.n5 9.3005
R2394 VGND.n671 VGND.n670 9.3005
R2395 VGND.n672 VGND.n4 9.3005
R2396 VGND.n673 VGND.n1 9.3005
R2397 VGND.n675 VGND.n674 9.3005
R2398 VGND.n2 VGND.n0 9.3005
R2399 VGND.n208 VGND.n207 9.3005
R2400 VGND.n209 VGND.n205 9.3005
R2401 VGND.n211 VGND.n210 9.3005
R2402 VGND.n212 VGND.n204 9.3005
R2403 VGND.n214 VGND.n213 9.3005
R2404 VGND.n215 VGND.n203 9.3005
R2405 VGND.n217 VGND.n216 9.3005
R2406 VGND.n218 VGND.n202 9.3005
R2407 VGND.n219 VGND.n200 9.3005
R2408 VGND.n221 VGND.n220 9.3005
R2409 VGND.n222 VGND.n199 9.3005
R2410 VGND.n224 VGND.n223 9.3005
R2411 VGND.n225 VGND.n198 9.3005
R2412 VGND.n226 VGND.n196 9.3005
R2413 VGND.n228 VGND.n227 9.3005
R2414 VGND.n230 VGND.n195 9.3005
R2415 VGND.n510 VGND.n509 9.3005
R2416 VGND.n512 VGND.n511 9.3005
R2417 VGND.n492 VGND.n491 9.3005
R2418 VGND.n493 VGND.n102 9.3005
R2419 VGND.n495 VGND.n494 9.3005
R2420 VGND.n497 VGND.n496 9.3005
R2421 VGND.n499 VGND.n498 9.3005
R2422 VGND.n500 VGND.n100 9.3005
R2423 VGND.n502 VGND.n501 9.3005
R2424 VGND.n504 VGND.n98 9.3005
R2425 VGND.n506 VGND.n505 9.3005
R2426 VGND.n490 VGND.n489 9.3005
R2427 VGND.n488 VGND.n105 9.3005
R2428 VGND.n486 VGND.n485 9.3005
R2429 VGND.n480 VGND.n107 9.3005
R2430 VGND.n479 VGND.n478 9.3005
R2431 VGND.n477 VGND.n108 9.3005
R2432 VGND.n475 VGND.n474 9.3005
R2433 VGND.n473 VGND.n109 9.3005
R2434 VGND.n472 VGND.n471 9.3005
R2435 VGND.n470 VGND.n110 9.3005
R2436 VGND.n468 VGND.n467 9.3005
R2437 VGND.n466 VGND.n111 9.3005
R2438 VGND.n465 VGND.n464 9.3005
R2439 VGND.n463 VGND.n112 9.3005
R2440 VGND.n462 VGND.n461 9.3005
R2441 VGND.n460 VGND.n113 9.3005
R2442 VGND.n459 VGND.n458 9.3005
R2443 VGND.n456 VGND.n114 9.3005
R2444 VGND.n455 VGND.n454 9.3005
R2445 VGND.n452 VGND.n115 9.3005
R2446 VGND.n451 VGND.n450 9.3005
R2447 VGND.n449 VGND.n116 9.3005
R2448 VGND.n448 VGND.n447 9.3005
R2449 VGND.n446 VGND.n118 9.3005
R2450 VGND.n445 VGND.n444 9.3005
R2451 VGND.n443 VGND.n442 9.3005
R2452 VGND.n441 VGND.n119 9.3005
R2453 VGND.n440 VGND.n439 9.3005
R2454 VGND.n437 VGND.n120 9.3005
R2455 VGND.n436 VGND.n435 9.3005
R2456 VGND.n434 VGND.n121 9.3005
R2457 VGND.n433 VGND.n432 9.3005
R2458 VGND.n430 VGND.n122 9.3005
R2459 VGND.n429 VGND.n428 9.3005
R2460 VGND.n427 VGND.n123 9.3005
R2461 VGND.n426 VGND.n425 9.3005
R2462 VGND.n424 VGND.n124 9.3005
R2463 VGND.n423 VGND.n422 9.3005
R2464 VGND.n421 VGND.n126 9.3005
R2465 VGND.n420 VGND.n419 9.3005
R2466 VGND.n418 VGND.n127 9.3005
R2467 VGND.n417 VGND.n416 9.3005
R2468 VGND.n415 VGND.n128 9.3005
R2469 VGND.n414 VGND.n413 9.3005
R2470 VGND.n412 VGND.n129 9.3005
R2471 VGND.n411 VGND.n410 9.3005
R2472 VGND.n409 VGND.n130 9.3005
R2473 VGND.n408 VGND.n407 9.3005
R2474 VGND.n406 VGND.n132 9.3005
R2475 VGND.n405 VGND.n404 9.3005
R2476 VGND.n403 VGND.n133 9.3005
R2477 VGND.n402 VGND.n401 9.3005
R2478 VGND.n400 VGND.n399 9.3005
R2479 VGND.n398 VGND.n136 9.3005
R2480 VGND.n397 VGND.n396 9.3005
R2481 VGND.n395 VGND.n137 9.3005
R2482 VGND.n394 VGND.n393 9.3005
R2483 VGND.n392 VGND.n138 9.3005
R2484 VGND.n391 VGND.n390 9.3005
R2485 VGND.n389 VGND.n139 9.3005
R2486 VGND.n388 VGND.n387 9.3005
R2487 VGND.n386 VGND.n140 9.3005
R2488 VGND.n385 VGND.n384 9.3005
R2489 VGND.n383 VGND.n142 9.3005
R2490 VGND.n382 VGND.n381 9.3005
R2491 VGND.n380 VGND.n143 9.3005
R2492 VGND.n379 VGND.n378 9.3005
R2493 VGND.n377 VGND.n144 9.3005
R2494 VGND.n375 VGND.n374 9.3005
R2495 VGND.n373 VGND.n145 9.3005
R2496 VGND.n372 VGND.n371 9.3005
R2497 VGND.n370 VGND.n146 9.3005
R2498 VGND.n368 VGND.n367 9.3005
R2499 VGND.n366 VGND.n147 9.3005
R2500 VGND.n365 VGND.n364 9.3005
R2501 VGND.n363 VGND.n148 9.3005
R2502 VGND.n361 VGND.n360 9.3005
R2503 VGND.n359 VGND.n149 9.3005
R2504 VGND.n358 VGND.n357 9.3005
R2505 VGND.n356 VGND.n150 9.3005
R2506 VGND.n355 VGND.n354 9.3005
R2507 VGND.n353 VGND.n151 9.3005
R2508 VGND.n352 VGND.n351 9.3005
R2509 VGND.n349 VGND.n152 9.3005
R2510 VGND.n348 VGND.n347 9.3005
R2511 VGND.n346 VGND.n153 9.3005
R2512 VGND.n345 VGND.n344 9.3005
R2513 VGND.n343 VGND.n154 9.3005
R2514 VGND.n342 VGND.n341 9.3005
R2515 VGND.n340 VGND.n156 9.3005
R2516 VGND.n339 VGND.n338 9.3005
R2517 VGND.n337 VGND.n336 9.3005
R2518 VGND.n335 VGND.n157 9.3005
R2519 VGND.n334 VGND.n333 9.3005
R2520 VGND.n331 VGND.n158 9.3005
R2521 VGND.n330 VGND.n329 9.3005
R2522 VGND.n328 VGND.n159 9.3005
R2523 VGND.n327 VGND.n326 9.3005
R2524 VGND.n324 VGND.n160 9.3005
R2525 VGND.n323 VGND.n322 9.3005
R2526 VGND.n321 VGND.n161 9.3005
R2527 VGND.n320 VGND.n319 9.3005
R2528 VGND.n318 VGND.n162 9.3005
R2529 VGND.n317 VGND.n316 9.3005
R2530 VGND.n315 VGND.n164 9.3005
R2531 VGND.n314 VGND.n313 9.3005
R2532 VGND.n312 VGND.n165 9.3005
R2533 VGND.n311 VGND.n310 9.3005
R2534 VGND.n309 VGND.n166 9.3005
R2535 VGND.n308 VGND.n307 9.3005
R2536 VGND.n306 VGND.n167 9.3005
R2537 VGND.n305 VGND.n304 9.3005
R2538 VGND.n303 VGND.n168 9.3005
R2539 VGND.n302 VGND.n301 9.3005
R2540 VGND.n300 VGND.n170 9.3005
R2541 VGND.n299 VGND.n298 9.3005
R2542 VGND.n297 VGND.n171 9.3005
R2543 VGND.n296 VGND.n295 9.3005
R2544 VGND.n294 VGND.n293 9.3005
R2545 VGND.n292 VGND.n174 9.3005
R2546 VGND.n291 VGND.n290 9.3005
R2547 VGND.n289 VGND.n175 9.3005
R2548 VGND.n288 VGND.n287 9.3005
R2549 VGND.n286 VGND.n176 9.3005
R2550 VGND.n285 VGND.n284 9.3005
R2551 VGND.n283 VGND.n177 9.3005
R2552 VGND.n282 VGND.n281 9.3005
R2553 VGND.n280 VGND.n178 9.3005
R2554 VGND.n279 VGND.n278 9.3005
R2555 VGND.n277 VGND.n180 9.3005
R2556 VGND.n276 VGND.n275 9.3005
R2557 VGND.n274 VGND.n181 9.3005
R2558 VGND.n273 VGND.n272 9.3005
R2559 VGND.n271 VGND.n182 9.3005
R2560 VGND.n269 VGND.n268 9.3005
R2561 VGND.n267 VGND.n183 9.3005
R2562 VGND.n266 VGND.n265 9.3005
R2563 VGND.n264 VGND.n184 9.3005
R2564 VGND.n262 VGND.n261 9.3005
R2565 VGND.n260 VGND.n185 9.3005
R2566 VGND.n259 VGND.n258 9.3005
R2567 VGND.n257 VGND.n186 9.3005
R2568 VGND.n255 VGND.n254 9.3005
R2569 VGND.n253 VGND.n187 9.3005
R2570 VGND.n252 VGND.n251 9.3005
R2571 VGND.n250 VGND.n188 9.3005
R2572 VGND.n249 VGND.n248 9.3005
R2573 VGND.n247 VGND.n189 9.3005
R2574 VGND.n246 VGND.n245 9.3005
R2575 VGND.n243 VGND.n190 9.3005
R2576 VGND.n242 VGND.n241 9.3005
R2577 VGND.n240 VGND.n191 9.3005
R2578 VGND.n239 VGND.n238 9.3005
R2579 VGND.n237 VGND.n192 9.3005
R2580 VGND.n236 VGND.n235 9.3005
R2581 VGND.n482 VGND.n481 9.3005
R2582 VGND.n234 VGND.n194 7.46433
R2583 VGND.n494 VGND.n101 6.77697
R2584 VGND.n517 VGND.n93 6.77697
R2585 VGND.n535 VGND.n82 6.77697
R2586 VGND.n553 VGND.n71 6.77697
R2587 VGND.n571 VGND.n60 6.77697
R2588 VGND.n589 VGND.n49 6.77697
R2589 VGND.n607 VGND.n38 6.77697
R2590 VGND.n625 VGND.n27 6.77697
R2591 VGND.n528 VGND.n86 4.62059
R2592 VGND.n546 VGND.n75 4.62059
R2593 VGND.n564 VGND.n64 4.62059
R2594 VGND.n582 VGND.n53 4.62059
R2595 VGND.n600 VGND.n42 4.62059
R2596 VGND.n618 VGND.n31 4.62059
R2597 VGND.n507 VGND.n97 4.62059
R2598 VGND.n487 VGND.n106 4.62059
R2599 VGND.n497 VGND.n101 4.51815
R2600 VGND.n93 VGND.n91 4.51815
R2601 VGND.n82 VGND.n80 4.51815
R2602 VGND.n71 VGND.n69 4.51815
R2603 VGND.n60 VGND.n58 4.51815
R2604 VGND.n49 VGND.n47 4.51815
R2605 VGND.n38 VGND.n36 4.51815
R2606 VGND.n27 VGND.n25 4.51815
R2607 VGND.n229 VGND 1.57468
R2608 VGND.n492 VGND.n104 0.753441
R2609 VGND.n504 VGND.n503 0.753441
R2610 VGND.n515 VGND.n95 0.753441
R2611 VGND.n90 VGND.n87 0.753441
R2612 VGND.n533 VGND.n84 0.753441
R2613 VGND.n79 VGND.n76 0.753441
R2614 VGND.n551 VGND.n73 0.753441
R2615 VGND.n68 VGND.n65 0.753441
R2616 VGND.n569 VGND.n62 0.753441
R2617 VGND.n57 VGND.n54 0.753441
R2618 VGND.n587 VGND.n51 0.753441
R2619 VGND.n46 VGND.n43 0.753441
R2620 VGND.n605 VGND.n40 0.753441
R2621 VGND.n35 VGND.n32 0.753441
R2622 VGND.n623 VGND.n29 0.753441
R2623 VGND.n24 VGND.n21 0.753441
R2624 VGND.n513 sky130_fd_sc_hs__and2_1_0.VGND 0.548969
R2625 VGND.n508 sky130_fd_sc_hs__and2_1_0.VGND 0.245598
R2626 VGND.n234 sky130_fd_sc_hs__and2_1_0.VGND 0.238616
R2627 VGND.n86 VGND.n85 0.184273
R2628 VGND.n75 VGND.n74 0.184273
R2629 VGND.n64 VGND.n63 0.184273
R2630 VGND.n53 VGND.n52 0.184273
R2631 VGND.n42 VGND.n41 0.184273
R2632 VGND.n31 VGND.n30 0.184273
R2633 VGND.n106 VGND.n105 0.184273
R2634 VGND.n235 VGND.n234 0.147317
R2635 VGND.n508 VGND.n507 0.133253
R2636 sky130_fd_sc_hs__and2_1_0.VGND VGND.n86 0.123049
R2637 sky130_fd_sc_hs__and2_1_0.VGND VGND.n75 0.123049
R2638 sky130_fd_sc_hs__and2_1_0.VGND VGND.n64 0.123049
R2639 sky130_fd_sc_hs__and2_1_0.VGND VGND.n53 0.123049
R2640 sky130_fd_sc_hs__and2_1_0.VGND VGND.n42 0.123049
R2641 sky130_fd_sc_hs__and2_1_0.VGND VGND.n31 0.123049
R2642 sky130_fd_sc_hs__and2_1_0.VGND VGND.n106 0.123049
R2643 VGND.n507 sky130_fd_sc_hs__and2_1_0.VGND 0.123049
R2644 VGND.n514 VGND.n92 0.122949
R2645 VGND.n518 VGND.n92 0.122949
R2646 VGND.n519 VGND.n518 0.122949
R2647 VGND.n520 VGND.n88 0.122949
R2648 VGND.n524 VGND.n88 0.122949
R2649 VGND.n525 VGND.n524 0.122949
R2650 VGND.n526 VGND.n525 0.122949
R2651 VGND.n531 VGND.n85 0.122949
R2652 VGND.n532 VGND.n531 0.122949
R2653 VGND.n532 VGND.n81 0.122949
R2654 VGND.n536 VGND.n81 0.122949
R2655 VGND.n537 VGND.n536 0.122949
R2656 VGND.n538 VGND.n77 0.122949
R2657 VGND.n542 VGND.n77 0.122949
R2658 VGND.n543 VGND.n542 0.122949
R2659 VGND.n544 VGND.n543 0.122949
R2660 VGND.n549 VGND.n74 0.122949
R2661 VGND.n550 VGND.n549 0.122949
R2662 VGND.n550 VGND.n70 0.122949
R2663 VGND.n554 VGND.n70 0.122949
R2664 VGND.n555 VGND.n554 0.122949
R2665 VGND.n556 VGND.n66 0.122949
R2666 VGND.n560 VGND.n66 0.122949
R2667 VGND.n561 VGND.n560 0.122949
R2668 VGND.n562 VGND.n561 0.122949
R2669 VGND.n567 VGND.n63 0.122949
R2670 VGND.n568 VGND.n567 0.122949
R2671 VGND.n568 VGND.n59 0.122949
R2672 VGND.n572 VGND.n59 0.122949
R2673 VGND.n573 VGND.n572 0.122949
R2674 VGND.n574 VGND.n55 0.122949
R2675 VGND.n578 VGND.n55 0.122949
R2676 VGND.n579 VGND.n578 0.122949
R2677 VGND.n580 VGND.n579 0.122949
R2678 VGND.n585 VGND.n52 0.122949
R2679 VGND.n586 VGND.n585 0.122949
R2680 VGND.n586 VGND.n48 0.122949
R2681 VGND.n590 VGND.n48 0.122949
R2682 VGND.n591 VGND.n590 0.122949
R2683 VGND.n592 VGND.n44 0.122949
R2684 VGND.n596 VGND.n44 0.122949
R2685 VGND.n597 VGND.n596 0.122949
R2686 VGND.n598 VGND.n597 0.122949
R2687 VGND.n603 VGND.n41 0.122949
R2688 VGND.n604 VGND.n603 0.122949
R2689 VGND.n604 VGND.n37 0.122949
R2690 VGND.n608 VGND.n37 0.122949
R2691 VGND.n609 VGND.n608 0.122949
R2692 VGND.n610 VGND.n33 0.122949
R2693 VGND.n614 VGND.n33 0.122949
R2694 VGND.n615 VGND.n614 0.122949
R2695 VGND.n616 VGND.n615 0.122949
R2696 VGND.n621 VGND.n30 0.122949
R2697 VGND.n622 VGND.n621 0.122949
R2698 VGND.n622 VGND.n26 0.122949
R2699 VGND.n626 VGND.n26 0.122949
R2700 VGND.n627 VGND.n626 0.122949
R2701 VGND.n628 VGND.n22 0.122949
R2702 VGND.n632 VGND.n22 0.122949
R2703 VGND.n633 VGND.n632 0.122949
R2704 VGND.n634 VGND.n633 0.122949
R2705 VGND.n638 VGND.n20 0.122949
R2706 VGND.n639 VGND.n638 0.122949
R2707 VGND.n640 VGND.n639 0.122949
R2708 VGND.n640 VGND.n17 0.122949
R2709 VGND.n645 VGND.n644 0.122949
R2710 VGND.n646 VGND.n645 0.122949
R2711 VGND.n646 VGND.n14 0.122949
R2712 VGND.n650 VGND.n14 0.122949
R2713 VGND.n651 VGND.n650 0.122949
R2714 VGND.n652 VGND.n651 0.122949
R2715 VGND.n652 VGND.n11 0.122949
R2716 VGND.n656 VGND.n11 0.122949
R2717 VGND.n657 VGND.n656 0.122949
R2718 VGND.n658 VGND.n657 0.122949
R2719 VGND.n658 VGND.n9 0.122949
R2720 VGND.n662 VGND.n9 0.122949
R2721 VGND.n663 VGND.n662 0.122949
R2722 VGND.n664 VGND.n663 0.122949
R2723 VGND.n664 VGND.n6 0.122949
R2724 VGND.n668 VGND.n6 0.122949
R2725 VGND.n670 VGND.n669 0.122949
R2726 VGND.n670 VGND.n4 0.122949
R2727 VGND.n4 VGND.n1 0.122949
R2728 VGND.n675 VGND.n1 0.122949
R2729 VGND.n208 VGND.n0 0.122949
R2730 VGND.n209 VGND.n208 0.122949
R2731 VGND.n210 VGND.n209 0.122949
R2732 VGND.n210 VGND.n204 0.122949
R2733 VGND.n214 VGND.n204 0.122949
R2734 VGND.n215 VGND.n214 0.122949
R2735 VGND.n216 VGND.n215 0.122949
R2736 VGND.n216 VGND.n202 0.122949
R2737 VGND.n202 VGND.n200 0.122949
R2738 VGND.n221 VGND.n200 0.122949
R2739 VGND.n222 VGND.n221 0.122949
R2740 VGND.n223 VGND.n222 0.122949
R2741 VGND.n223 VGND.n198 0.122949
R2742 VGND.n198 VGND.n196 0.122949
R2743 VGND.n228 VGND.n196 0.122949
R2744 VGND.n490 VGND.n105 0.122949
R2745 VGND.n491 VGND.n490 0.122949
R2746 VGND.n491 VGND.n102 0.122949
R2747 VGND.n495 VGND.n102 0.122949
R2748 VGND.n496 VGND.n495 0.122949
R2749 VGND.n500 VGND.n499 0.122949
R2750 VGND.n501 VGND.n500 0.122949
R2751 VGND.n501 VGND.n98 0.122949
R2752 VGND.n506 VGND.n98 0.122949
R2753 VGND.n480 VGND.n479 0.122949
R2754 VGND.n479 VGND.n108 0.122949
R2755 VGND.n474 VGND.n108 0.122949
R2756 VGND.n474 VGND.n473 0.122949
R2757 VGND.n472 VGND.n110 0.122949
R2758 VGND.n467 VGND.n110 0.122949
R2759 VGND.n467 VGND.n466 0.122949
R2760 VGND.n466 VGND.n465 0.122949
R2761 VGND.n465 VGND.n112 0.122949
R2762 VGND.n461 VGND.n112 0.122949
R2763 VGND.n461 VGND.n460 0.122949
R2764 VGND.n460 VGND.n459 0.122949
R2765 VGND.n459 VGND.n114 0.122949
R2766 VGND.n454 VGND.n114 0.122949
R2767 VGND.n452 VGND.n451 0.122949
R2768 VGND.n451 VGND.n116 0.122949
R2769 VGND.n447 VGND.n116 0.122949
R2770 VGND.n447 VGND.n446 0.122949
R2771 VGND.n446 VGND.n445 0.122949
R2772 VGND.n442 VGND.n441 0.122949
R2773 VGND.n441 VGND.n440 0.122949
R2774 VGND.n440 VGND.n120 0.122949
R2775 VGND.n435 VGND.n120 0.122949
R2776 VGND.n434 VGND.n433 0.122949
R2777 VGND.n433 VGND.n122 0.122949
R2778 VGND.n428 VGND.n122 0.122949
R2779 VGND.n428 VGND.n427 0.122949
R2780 VGND.n427 VGND.n426 0.122949
R2781 VGND.n426 VGND.n124 0.122949
R2782 VGND.n422 VGND.n124 0.122949
R2783 VGND.n422 VGND.n421 0.122949
R2784 VGND.n421 VGND.n420 0.122949
R2785 VGND.n420 VGND.n127 0.122949
R2786 VGND.n416 VGND.n127 0.122949
R2787 VGND.n416 VGND.n415 0.122949
R2788 VGND.n415 VGND.n414 0.122949
R2789 VGND.n414 VGND.n129 0.122949
R2790 VGND.n410 VGND.n129 0.122949
R2791 VGND.n410 VGND.n409 0.122949
R2792 VGND.n408 VGND.n132 0.122949
R2793 VGND.n404 VGND.n132 0.122949
R2794 VGND.n404 VGND.n403 0.122949
R2795 VGND.n403 VGND.n402 0.122949
R2796 VGND.n399 VGND.n398 0.122949
R2797 VGND.n398 VGND.n397 0.122949
R2798 VGND.n397 VGND.n137 0.122949
R2799 VGND.n393 VGND.n137 0.122949
R2800 VGND.n393 VGND.n392 0.122949
R2801 VGND.n392 VGND.n391 0.122949
R2802 VGND.n391 VGND.n139 0.122949
R2803 VGND.n387 VGND.n139 0.122949
R2804 VGND.n387 VGND.n386 0.122949
R2805 VGND.n386 VGND.n385 0.122949
R2806 VGND.n385 VGND.n142 0.122949
R2807 VGND.n381 VGND.n142 0.122949
R2808 VGND.n381 VGND.n380 0.122949
R2809 VGND.n380 VGND.n379 0.122949
R2810 VGND.n379 VGND.n144 0.122949
R2811 VGND.n374 VGND.n144 0.122949
R2812 VGND.n373 VGND.n372 0.122949
R2813 VGND.n372 VGND.n146 0.122949
R2814 VGND.n367 VGND.n146 0.122949
R2815 VGND.n367 VGND.n366 0.122949
R2816 VGND.n365 VGND.n148 0.122949
R2817 VGND.n360 VGND.n148 0.122949
R2818 VGND.n360 VGND.n359 0.122949
R2819 VGND.n359 VGND.n358 0.122949
R2820 VGND.n358 VGND.n150 0.122949
R2821 VGND.n354 VGND.n150 0.122949
R2822 VGND.n354 VGND.n353 0.122949
R2823 VGND.n353 VGND.n352 0.122949
R2824 VGND.n352 VGND.n152 0.122949
R2825 VGND.n347 VGND.n152 0.122949
R2826 VGND.n347 VGND.n346 0.122949
R2827 VGND.n346 VGND.n345 0.122949
R2828 VGND.n345 VGND.n154 0.122949
R2829 VGND.n341 VGND.n154 0.122949
R2830 VGND.n341 VGND.n340 0.122949
R2831 VGND.n340 VGND.n339 0.122949
R2832 VGND.n336 VGND.n335 0.122949
R2833 VGND.n335 VGND.n334 0.122949
R2834 VGND.n334 VGND.n158 0.122949
R2835 VGND.n329 VGND.n158 0.122949
R2836 VGND.n328 VGND.n327 0.122949
R2837 VGND.n327 VGND.n160 0.122949
R2838 VGND.n322 VGND.n160 0.122949
R2839 VGND.n322 VGND.n321 0.122949
R2840 VGND.n321 VGND.n320 0.122949
R2841 VGND.n320 VGND.n162 0.122949
R2842 VGND.n316 VGND.n162 0.122949
R2843 VGND.n316 VGND.n315 0.122949
R2844 VGND.n315 VGND.n314 0.122949
R2845 VGND.n314 VGND.n165 0.122949
R2846 VGND.n310 VGND.n165 0.122949
R2847 VGND.n310 VGND.n309 0.122949
R2848 VGND.n309 VGND.n308 0.122949
R2849 VGND.n308 VGND.n167 0.122949
R2850 VGND.n304 VGND.n167 0.122949
R2851 VGND.n304 VGND.n303 0.122949
R2852 VGND.n302 VGND.n170 0.122949
R2853 VGND.n298 VGND.n170 0.122949
R2854 VGND.n298 VGND.n297 0.122949
R2855 VGND.n297 VGND.n296 0.122949
R2856 VGND.n293 VGND.n292 0.122949
R2857 VGND.n292 VGND.n291 0.122949
R2858 VGND.n291 VGND.n175 0.122949
R2859 VGND.n287 VGND.n175 0.122949
R2860 VGND.n287 VGND.n286 0.122949
R2861 VGND.n286 VGND.n285 0.122949
R2862 VGND.n285 VGND.n177 0.122949
R2863 VGND.n281 VGND.n177 0.122949
R2864 VGND.n281 VGND.n280 0.122949
R2865 VGND.n280 VGND.n279 0.122949
R2866 VGND.n279 VGND.n180 0.122949
R2867 VGND.n275 VGND.n180 0.122949
R2868 VGND.n275 VGND.n274 0.122949
R2869 VGND.n274 VGND.n273 0.122949
R2870 VGND.n273 VGND.n182 0.122949
R2871 VGND.n268 VGND.n182 0.122949
R2872 VGND.n267 VGND.n266 0.122949
R2873 VGND.n266 VGND.n184 0.122949
R2874 VGND.n261 VGND.n184 0.122949
R2875 VGND.n261 VGND.n260 0.122949
R2876 VGND.n259 VGND.n186 0.122949
R2877 VGND.n254 VGND.n186 0.122949
R2878 VGND.n254 VGND.n253 0.122949
R2879 VGND.n253 VGND.n252 0.122949
R2880 VGND.n252 VGND.n188 0.122949
R2881 VGND.n248 VGND.n188 0.122949
R2882 VGND.n248 VGND.n247 0.122949
R2883 VGND.n247 VGND.n246 0.122949
R2884 VGND.n246 VGND.n190 0.122949
R2885 VGND.n241 VGND.n190 0.122949
R2886 VGND.n241 VGND.n240 0.122949
R2887 VGND.n240 VGND.n239 0.122949
R2888 VGND.n239 VGND.n192 0.122949
R2889 VGND.n235 VGND.n192 0.122949
R2890 VGND.n513 VGND.n512 0.115696
R2891 VGND.n454 VGND.n453 0.107643
R2892 VGND.n230 VGND.n229 0.0732041
R2893 VGND.n512 VGND.n96 0.0617745
R2894 sky130_fd_sc_hs__and2_1_0.VGND VGND.n519 0.0617245
R2895 VGND.n520 sky130_fd_sc_hs__and2_1_0.VGND 0.0617245
R2896 sky130_fd_sc_hs__and2_1_0.VGND VGND.n537 0.0617245
R2897 VGND.n538 sky130_fd_sc_hs__and2_1_0.VGND 0.0617245
R2898 VGND.n556 sky130_fd_sc_hs__and2_1_0.VGND 0.0617245
R2899 VGND.n562 sky130_fd_sc_hs__and2_1_0.VGND 0.0617245
R2900 sky130_fd_sc_hs__and2_1_0.VGND VGND.n573 0.0617245
R2901 VGND.n574 sky130_fd_sc_hs__and2_1_0.VGND 0.0617245
R2902 sky130_fd_sc_hs__and2_1_0.VGND VGND.n591 0.0617245
R2903 VGND.n592 sky130_fd_sc_hs__and2_1_0.VGND 0.0617245
R2904 VGND.n610 sky130_fd_sc_hs__and2_1_0.VGND 0.0617245
R2905 VGND.n616 sky130_fd_sc_hs__and2_1_0.VGND 0.0617245
R2906 VGND.n628 sky130_fd_sc_hs__and2_1_0.VGND 0.0617245
R2907 sky130_fd_sc_hs__and2_1_0.VGND VGND.n20 0.0617245
R2908 VGND.n17 sky130_fd_sc_hs__and2_1_0.VGND 0.0617245
R2909 VGND.n644 sky130_fd_sc_hs__and2_1_0.VGND 0.0617245
R2910 sky130_fd_sc_hs__and2_1_0.VGND VGND.n668 0.0617245
R2911 VGND.n669 sky130_fd_sc_hs__and2_1_0.VGND 0.0617245
R2912 sky130_fd_sc_hs__and2_1_0.VGND VGND.n675 0.0617245
R2913 sky130_fd_sc_hs__and2_1_0.VGND VGND.n0 0.0617245
R2914 sky130_fd_sc_hs__and2_1_0.VGND VGND.n230 0.0617245
R2915 VGND.n485 sky130_fd_sc_hs__and2_1_0.VGND 0.0617245
R2916 VGND.n485 sky130_fd_sc_hs__and2_1_0.VGND 0.0617245
R2917 VGND.n499 sky130_fd_sc_hs__and2_1_0.VGND 0.0617245
R2918 sky130_fd_sc_hs__and2_1_0.VGND VGND.n506 0.0617245
R2919 VGND.n481 sky130_fd_sc_hs__and2_1_0.VGND 0.0617245
R2920 sky130_fd_sc_hs__and2_1_0.VGND VGND.n480 0.0617245
R2921 VGND.n473 sky130_fd_sc_hs__and2_1_0.VGND 0.0617245
R2922 sky130_fd_sc_hs__and2_1_0.VGND VGND.n472 0.0617245
R2923 VGND.n445 sky130_fd_sc_hs__and2_1_0.VGND 0.0617245
R2924 VGND.n442 sky130_fd_sc_hs__and2_1_0.VGND 0.0617245
R2925 VGND.n435 sky130_fd_sc_hs__and2_1_0.VGND 0.0617245
R2926 sky130_fd_sc_hs__and2_1_0.VGND VGND.n434 0.0617245
R2927 VGND.n409 sky130_fd_sc_hs__and2_1_0.VGND 0.0617245
R2928 sky130_fd_sc_hs__and2_1_0.VGND VGND.n408 0.0617245
R2929 VGND.n402 sky130_fd_sc_hs__and2_1_0.VGND 0.0617245
R2930 VGND.n399 sky130_fd_sc_hs__and2_1_0.VGND 0.0617245
R2931 VGND.n374 sky130_fd_sc_hs__and2_1_0.VGND 0.0617245
R2932 sky130_fd_sc_hs__and2_1_0.VGND VGND.n373 0.0617245
R2933 VGND.n366 sky130_fd_sc_hs__and2_1_0.VGND 0.0617245
R2934 sky130_fd_sc_hs__and2_1_0.VGND VGND.n365 0.0617245
R2935 VGND.n339 sky130_fd_sc_hs__and2_1_0.VGND 0.0617245
R2936 VGND.n336 sky130_fd_sc_hs__and2_1_0.VGND 0.0617245
R2937 VGND.n329 sky130_fd_sc_hs__and2_1_0.VGND 0.0617245
R2938 sky130_fd_sc_hs__and2_1_0.VGND VGND.n328 0.0617245
R2939 VGND.n303 sky130_fd_sc_hs__and2_1_0.VGND 0.0617245
R2940 sky130_fd_sc_hs__and2_1_0.VGND VGND.n302 0.0617245
R2941 VGND.n296 sky130_fd_sc_hs__and2_1_0.VGND 0.0617245
R2942 VGND.n293 sky130_fd_sc_hs__and2_1_0.VGND 0.0617245
R2943 VGND.n268 sky130_fd_sc_hs__and2_1_0.VGND 0.0617245
R2944 sky130_fd_sc_hs__and2_1_0.VGND VGND.n267 0.0617245
R2945 VGND.n260 sky130_fd_sc_hs__and2_1_0.VGND 0.0617245
R2946 sky130_fd_sc_hs__and2_1_0.VGND VGND.n259 0.0617245
R2947 VGND.n544 sky130_fd_sc_hs__and2_1_0.VGND 0.0591735
R2948 sky130_fd_sc_hs__and2_1_0.VGND VGND.n555 0.0591735
R2949 VGND.n580 sky130_fd_sc_hs__and2_1_0.VGND 0.0591735
R2950 VGND.n598 sky130_fd_sc_hs__and2_1_0.VGND 0.0591735
R2951 VGND.n634 sky130_fd_sc_hs__and2_1_0.VGND 0.0591735
R2952 VGND.n496 sky130_fd_sc_hs__and2_1_0.VGND 0.0591735
R2953 VGND.n481 sky130_fd_sc_hs__and2_1_0.VGND 0.0591735
R2954 VGND.n509 VGND.n96 0.0568725
R2955 VGND.n526 sky130_fd_sc_hs__and2_1_0.VGND 0.0566224
R2956 sky130_fd_sc_hs__and2_1_0.VGND VGND.n609 0.0515204
R2957 VGND.n229 VGND.n228 0.0502449
R2958 VGND.n509 VGND.n508 0.0495196
R2959 sky130_fd_sc_hs__and2_1_0.VGND VGND.n627 0.0362143
R2960 VGND.n453 VGND.n452 0.0158061
R2961 VGND.n514 VGND.n513 0.00305102
R2962 a_15132_n1189.t0 a_15132_n1189.t1 75.7148
R2963 a_14695_n1212.t0 a_14695_n1212.t1 60.0005
R2964 a_15082_n805.t0 a_15082_n805.t1 222.798
R2965 a_14975_n889.n0 a_14975_n889.t0 56.4605
R2966 a_14975_n889.t1 a_14975_n889.n0 70.0005
R2967 a_14975_n889.n0 a_14975_n889.n2 218.673
R2968 a_14975_n889.n2 a_14975_n889.n3 244.236
R2969 a_14975_n889.n3 a_14975_n889.t4 182.481
R2970 a_14975_n889.n3 a_14975_n889.t5 246.456
R2971 a_14975_n889.n1 a_14975_n889.t3 34.0065
R2972 a_14975_n889.n2 a_14975_n889.n1 695.769
R2973 a_14975_n889.n1 a_14975_n889.t2 112.572
R2974 a_13020_n1189.t0 a_13020_n1189.t1 75.7148
R2975 a_12583_n1212.t0 a_12583_n1212.t1 60.0005
R2976 a_14632_n810.t0 a_14632_n810.t1 112.572
R2977 a_14418_n810.n0 a_14418_n810.n1 30.0513
R2978 a_14418_n810.n1 a_14418_n810.n3 36.7293
R2979 a_14418_n810.n3 a_14418_n810.t0 6.36218
R2980 a_14418_n810.n3 a_14418_n810.t2 155
R2981 a_14418_n810.n1 a_14418_n810.n2 918.856
R2982 a_14418_n810.n2 a_14418_n810.t1 72.8576
R2983 a_14418_n810.n2 a_14418_n810.t3 71.2386
R2984 a_15174_n999.t1 a_15174_n999.n1 288.435
R2985 a_15174_n999.n1 a_15174_n999.n0 152
R2986 a_15174_n999.n1 a_15174_n999.n3 36.7273
R2987 a_15174_n999.n3 a_15174_n999.t0 401.988
R2988 a_15174_n999.n3 a_15174_n999.n2 97.1059
R2989 a_15174_n999.n2 a_15174_n999.t3 282.675
R2990 a_15174_n999.n2 a_15174_n999.t5 198.083
R2991 a_15174_n999.n0 a_15174_n999.t2 220.113
R2992 a_15174_n999.n0 a_15174_n999.t4 250.909
R2993 a_14525_n850.t0 a_14525_n850.n3 68.0124
R2994 a_14525_n850.n3 a_14525_n850.t2 157.345
R2995 a_14525_n850.n3 a_14525_n850.n2 589.926
R2996 a_14525_n850.n2 a_14525_n850.n1 300.101
R2997 a_14525_n850.n1 a_14525_n850.t1 43.7148
R2998 a_14525_n850.n1 a_14525_n850.t3 57.7148
R2999 a_14525_n850.n2 a_14525_n850.n0 260.5
R3000 a_14525_n850.n0 a_14525_n850.t5 203.294
R3001 a_14525_n850.n0 a_14525_n850.t4 380.639
R3002 a_14677_n855.n3 a_14677_n855.n2 230.298
R3003 a_14677_n855.n3 a_14677_n855.t2 24.2336
R3004 a_14677_n855.t1 a_14677_n855.n3 49.4918
R3005 a_14677_n855.n2 a_14677_n855.n1 662.327
R3006 a_14677_n855.n1 a_14677_n855.t0 37.5243
R3007 a_14677_n855.n1 a_14677_n855.t3 92.6374
R3008 a_14677_n855.n2 a_14677_n855.n0 177.44
R3009 a_14677_n855.n0 a_14677_n855.t4 139.028
R3010 a_14677_n855.n0 a_14677_n855.t5 478.647
R3011 a_14170_n945.t0 a_14170_n945.n1 258.969
R3012 a_14170_n945.n1 a_14170_n945.n0 152
R3013 a_14170_n945.n2 a_14170_n945.t1 217.333
R3014 a_14170_n945.n1 a_14170_n945.n2 30.1502
R3015 a_14170_n945.n2 a_14170_n945.n3 264.704
R3016 a_14170_n945.n3 a_14170_n945.t4 372.413
R3017 a_14170_n945.n3 a_14170_n945.t2 412.152
R3018 a_14170_n945.n0 a_14170_n945.t3 1132.7
R3019 a_14170_n945.n0 a_14170_n945.t5 541.106
R3020 sky130_fd_sc_hs__dfxtp_1_0.D sky130_fd_sc_hs__dfxtp_1_0.D.n0 190.779
R3021 sky130_fd_sc_hs__dfxtp_1_0.D.n0 sky130_fd_sc_hs__dfxtp_1_0.D.t1 34.8654
R3022 sky130_fd_sc_hs__dfxtp_1_0.D.n0 sky130_fd_sc_hs__dfxtp_1_0.D.t0 22.7032
R3023 sky130_fd_sc_hs__dfxtp_1_0.D.n1 sky130_fd_sc_hs__dfxtp_1_0.D.n2 585
R3024 sky130_fd_sc_hs__dfxtp_1_0.D.n2 sky130_fd_sc_hs__dfxtp_1_0.D.n3 585
R3025 sky130_fd_sc_hs__dfxtp_1_0.D sky130_fd_sc_hs__dfxtp_1_0.D.n1 1.01868
R3026 sky130_fd_sc_hs__dfxtp_1_0.D.n1 sky130_fd_sc_hs__dfxtp_1_0.D 9.74595
R3027 sky130_fd_sc_hs__dfxtp_1_0.D sky130_fd_sc_hs__dfxtp_1_0.D.n3 2.32777
R3028 sky130_fd_sc_hs__dfxtp_1_0.D.n3 sky130_fd_sc_hs__dfxtp_1_0.D.n4 2.76414
R3029 sky130_fd_sc_hs__dfxtp_1_0.D.n4 sky130_fd_sc_hs__dfxtp_1_0.D 5.67323
R3030 sky130_fd_sc_hs__dfxtp_1_0.D sky130_fd_sc_hs__dfxtp_1_0.D.n2 588.636
R3031 sky130_fd_sc_hs__dfxtp_1_0.D.n4 sky130_fd_sc_hs__dfxtp_1_0.D.n6 20.3971
R3032 sky130_fd_sc_hs__dfxtp_1_0.D sky130_fd_sc_hs__dfxtp_1_0.D.n5 2.52682
R3033 sky130_fd_sc_hs__dfxtp_1_0.D.n6 sky130_fd_sc_hs__dfxtp_1_0.D.n5 2.86366
R3034 sky130_fd_sc_hs__dfxtp_1_0.D sky130_fd_sc_hs__dfxtp_1_0.D.n5 3.42907
R3035 sky130_fd_sc_hs__dfxtp_1_0.D.t3 sky130_fd_sc_hs__dfxtp_1_0.D 355.692
R3036 sky130_fd_sc_hs__dfxtp_1_0.D.n6 sky130_fd_sc_hs__dfxtp_1_0.D.t4 288.2
R3037 sky130_fd_sc_hs__dfxtp_1_0.D.n2 sky130_fd_sc_hs__dfxtp_1_0.D.t2 27.2639
R3038 a_13762_n945.t0 a_13762_n945.t1 47.4916
R3039 a_12970_n805.t0 a_12970_n805.t1 222.798
R3040 a_12863_n889.n3 a_12863_n889.t2 34.0065
R3041 a_12863_n889.t0 a_12863_n889.n3 112.572
R3042 a_12863_n889.n3 a_12863_n889.n1 695.769
R3043 a_12863_n889.n1 a_12863_n889.n2 244.236
R3044 a_12863_n889.n2 a_12863_n889.t4 182.481
R3045 a_12863_n889.n2 a_12863_n889.t5 246.456
R3046 a_12863_n889.n1 a_12863_n889.n0 218.673
R3047 a_12863_n889.n0 a_12863_n889.t1 56.4605
R3048 a_12863_n889.n0 a_12863_n889.t3 70.0005
R3049 a_11037_n1177.n1 a_11037_n1177.t0 21.7331
R3050 a_11037_n1177.n0 a_11037_n1177.n1 19.2005
R3051 a_11037_n1177.n1 a_11037_n1177.t1 58.1616
R3052 a_10601_n1226.t0 a_10601_n1226.t1 38.9194
R3053 a_12520_n810.t0 a_12520_n810.t1 112.572
R3054 a_12306_n810.t0 a_12306_n810.n1 72.8576
R3055 a_12306_n810.n1 a_12306_n810.t2 71.2386
R3056 a_12306_n810.n1 a_12306_n810.n0 918.856
R3057 a_12306_n810.n0 a_12306_n810.t1 70.3576
R3058 a_12306_n810.n0 a_12306_n810.t3 155
R3059 a_13991_n1239.t1 a_13991_n1239.n4 172.839
R3060 a_13991_n1239.n1 a_13991_n1239.n0 152
R3061 a_13991_n1239.n4 a_13991_n1239.n1 9.46137
R3062 a_13991_n1239.n4 a_13991_n1239.n3 303.166
R3063 a_13991_n1239.n3 a_13991_n1239.t2 449.469
R3064 a_13991_n1239.t2 a_13991_n1239.t4 733.712
R3065 a_13991_n1239.n3 a_13991_n1239.n2 236.078
R3066 a_13991_n1239.n2 a_13991_n1239.t3 315.515
R3067 a_13991_n1239.n2 a_13991_n1239.t6 209.476
R3068 a_13991_n1239.n1 a_13991_n1239.t0 290.298
R3069 a_13991_n1239.n0 a_13991_n1239.t5 174.898
R3070 a_13991_n1239.n0 a_13991_n1239.t7 282.276
R3071 a_13511_n1201.t1 a_13511_n1201.n1 276.375
R3072 a_13511_n1201.n1 a_13511_n1201.n0 234.287
R3073 a_13511_n1201.n0 a_13511_n1201.t2 210.474
R3074 a_13511_n1201.n0 a_13511_n1201.t3 258.942
R3075 a_13511_n1201.n1 a_13511_n1201.t0 409.457
R3076 a_13062_n999.t1 a_13062_n999.n1 288.435
R3077 a_13062_n999.n1 a_13062_n999.n0 152
R3078 a_13062_n999.n1 a_13062_n999.n3 36.7273
R3079 a_13062_n999.n3 a_13062_n999.t0 401.988
R3080 a_13062_n999.n3 a_13062_n999.n2 97.1059
R3081 a_13062_n999.n2 a_13062_n999.t3 282.675
R3082 a_13062_n999.n2 a_13062_n999.t5 198.083
R3083 a_13062_n999.n0 a_13062_n999.t2 220.113
R3084 a_13062_n999.n0 a_13062_n999.t4 250.909
R3085 a_12413_n850.n5 a_12413_n850.t0 23.1765
R3086 a_12413_n850.n0 a_12413_n850.n5 28.8005
R3087 a_12413_n850.n5 a_12413_n850.n1 8.0005
R3088 a_12413_n850.n1 a_12413_n850.t2 57.7148
R3089 a_12413_n850.n1 a_12413_n850.n3 300.101
R3090 a_12413_n850.n3 a_12413_n850.n4 260.5
R3091 a_12413_n850.n4 a_12413_n850.t5 203.294
R3092 a_12413_n850.n4 a_12413_n850.t4 380.639
R3093 a_12413_n850.n2 a_12413_n850.t1 68.0124
R3094 a_12413_n850.n3 a_12413_n850.n2 589.926
R3095 a_12413_n850.n2 a_12413_n850.t3 157.345
R3096 a_12565_n855.n3 a_12565_n855.n2 230.298
R3097 a_12565_n855.t0 a_12565_n855.n3 24.2336
R3098 a_12565_n855.n3 a_12565_n855.t2 49.4918
R3099 a_12565_n855.n2 a_12565_n855.n1 662.327
R3100 a_12565_n855.n1 a_12565_n855.t1 37.5243
R3101 a_12565_n855.n1 a_12565_n855.t3 92.6374
R3102 a_12565_n855.n2 a_12565_n855.n0 177.44
R3103 a_12565_n855.n0 a_12565_n855.t4 139.028
R3104 a_12565_n855.n0 a_12565_n855.t5 478.647
R3105 a_12058_n945.t1 a_12058_n945.n1 258.969
R3106 a_12058_n945.n1 a_12058_n945.n0 152
R3107 a_12058_n945.n2 a_12058_n945.t0 217.333
R3108 a_12058_n945.n1 a_12058_n945.n2 30.1502
R3109 a_12058_n945.n2 a_12058_n945.n3 264.704
R3110 a_12058_n945.n3 a_12058_n945.t4 372.413
R3111 a_12058_n945.n3 a_12058_n945.t2 412.152
R3112 a_12058_n945.n0 a_12058_n945.t3 1132.7
R3113 a_12058_n945.n0 a_12058_n945.t5 541.106
R3114 sky130_fd_sc_hs__nor2b_1_7.Y sky130_fd_sc_hs__nor2b_1_7.Y.n0 190.779
R3115 sky130_fd_sc_hs__nor2b_1_7.Y.n0 sky130_fd_sc_hs__nor2b_1_7.Y.t2 34.8654
R3116 sky130_fd_sc_hs__nor2b_1_7.Y.n0 sky130_fd_sc_hs__nor2b_1_7.Y.t0 22.7032
R3117 sky130_fd_sc_hs__nor2b_1_7.Y.n1 sky130_fd_sc_hs__nor2b_1_7.Y.n2 585
R3118 sky130_fd_sc_hs__nor2b_1_7.Y.n2 sky130_fd_sc_hs__nor2b_1_7.Y.n3 585
R3119 sky130_fd_sc_hs__nor2b_1_7.Y sky130_fd_sc_hs__nor2b_1_7.Y.n1 1.01868
R3120 sky130_fd_sc_hs__nor2b_1_7.Y.n1 sky130_fd_sc_hs__nor2b_1_7.Y 9.74595
R3121 sky130_fd_sc_hs__nor2b_1_7.Y sky130_fd_sc_hs__nor2b_1_7.Y.n4 0.727773
R3122 sky130_fd_sc_hs__nor2b_1_7.Y.n3 sky130_fd_sc_hs__nor2b_1_7.Y.n4 1.6005
R3123 sky130_fd_sc_hs__nor2b_1_7.Y.n3 sky130_fd_sc_hs__nor2b_1_7.Y 8.43686
R3124 sky130_fd_sc_hs__nor2b_1_7.Y sky130_fd_sc_hs__nor2b_1_7.Y.n2 588.636
R3125 sky130_fd_sc_hs__nor2b_1_7.Y sky130_fd_sc_hs__nor2b_1_7.Y.n6 2.52682
R3126 sky130_fd_sc_hs__nor2b_1_7.Y.n5 sky130_fd_sc_hs__nor2b_1_7.Y.n6 5.55839
R3127 sky130_fd_sc_hs__nor2b_1_7.Y.n4 sky130_fd_sc_hs__nor2b_1_7.Y.n5 24.9064
R3128 sky130_fd_sc_hs__nor2b_1_7.Y sky130_fd_sc_hs__nor2b_1_7.Y.n6 3.42907
R3129 sky130_fd_sc_hs__nor2b_1_7.Y.t3 sky130_fd_sc_hs__nor2b_1_7.Y 355.692
R3130 sky130_fd_sc_hs__nor2b_1_7.Y.n5 sky130_fd_sc_hs__nor2b_1_7.Y.t4 285.505
R3131 sky130_fd_sc_hs__nor2b_1_7.Y.n2 sky130_fd_sc_hs__nor2b_1_7.Y.t1 27.2639
R3132 a_11650_n945.t0 a_11650_n945.t1 47.4916
R3133 sky130_fd_sc_hs__and2_1_7.X.n0 sky130_fd_sc_hs__and2_1_7.X.t1 286.339
R3134 sky130_fd_sc_hs__and2_1_7.X.t1 sky130_fd_sc_hs__and2_1_7.X.n6 258.685
R3135 sky130_fd_sc_hs__and2_1_7.X.n6 sky130_fd_sc_hs__and2_1_7.X.n0 4.17734
R3136 sky130_fd_sc_hs__and2_1_7.X.n3 sky130_fd_sc_hs__and2_1_7.X.n4 585
R3137 sky130_fd_sc_hs__and2_1_7.X.n4 sky130_fd_sc_hs__and2_1_7.X.n5 585
R3138 sky130_fd_sc_hs__and2_1_7.X sky130_fd_sc_hs__and2_1_7.X.n6 57.326
R3139 sky130_fd_sc_hs__and2_1_7.X sky130_fd_sc_hs__and2_1_7.X.n3 2.10683
R3140 sky130_fd_sc_hs__and2_1_7.X.n3 sky130_fd_sc_hs__and2_1_7.X 9.88404
R3141 sky130_fd_sc_hs__and2_1_7.X sky130_fd_sc_hs__and2_1_7.X.n5 3.07898
R3142 sky130_fd_sc_hs__and2_1_7.X.n5 sky130_fd_sc_hs__and2_1_7.X 8.91189
R3143 sky130_fd_sc_hs__and2_1_7.X sky130_fd_sc_hs__and2_1_7.X.n4 589.052
R3144 sky130_fd_sc_hs__and2_1_7.X.n4 sky130_fd_sc_hs__and2_1_7.X.t0 26.3844
R3145 sky130_fd_sc_hs__and2_1_7.X.n0 sky130_fd_sc_hs__and2_1_7.X.n2 50.731
R3146 sky130_fd_sc_hs__and2_1_7.X sky130_fd_sc_hs__and2_1_7.X.n2 6.4005
R3147 sky130_fd_sc_hs__and2_1_7.X.n2 sky130_fd_sc_hs__and2_1_7.X.n1 213.004
R3148 sky130_fd_sc_hs__and2_1_7.X.n1 sky130_fd_sc_hs__and2_1_7.X.t2 128.288
R3149 sky130_fd_sc_hs__and2_1_7.X.n1 sky130_fd_sc_hs__and2_1_7.X.t3 219.846
R3150 a_9809_n1177.n0 a_9809_n1177.n1 19.2005
R3151 a_9809_n1177.n1 a_9809_n1177.t0 21.7331
R3152 a_9809_n1177.n1 a_9809_n1177.t1 58.1616
R3153 a_9361_n1226.t0 a_9361_n1226.t1 38.9194
R3154 sky130_fd_sc_hs__nor2b_1_7.B_N.n1 sky130_fd_sc_hs__nor2b_1_7.B_N.n0 185
R3155 sky130_fd_sc_hs__nor2b_1_7.B_N.n0 sky130_fd_sc_hs__nor2b_1_7.B_N.n5 185
R3156 sky130_fd_sc_hs__nor2b_1_7.B_N.n0 sky130_fd_sc_hs__nor2b_1_7.B_N.t1 22.7032
R3157 sky130_fd_sc_hs__nor2b_1_7.B_N.n0 sky130_fd_sc_hs__nor2b_1_7.B_N.t0 45.4059
R3158 sky130_fd_sc_hs__nor2b_1_7.B_N sky130_fd_sc_hs__nor2b_1_7.B_N.n1 3.16454
R3159 sky130_fd_sc_hs__nor2b_1_7.B_N.n1 sky130_fd_sc_hs__nor2b_1_7.B_N 7.47915
R3160 sky130_fd_sc_hs__nor2b_1_7.B_N sky130_fd_sc_hs__nor2b_1_7.B_N.n5 4.17129
R3161 sky130_fd_sc_hs__nor2b_1_7.B_N.n2 sky130_fd_sc_hs__nor2b_1_7.B_N.t2 230.18
R3162 sky130_fd_sc_hs__nor2b_1_7.B_N.n5 sky130_fd_sc_hs__nor2b_1_7.B_N.n2 118.275
R3163 sky130_fd_sc_hs__nor2b_1_7.B_N.n2 sky130_fd_sc_hs__nor2b_1_7.B_N.n4 33.1544
R3164 sky130_fd_sc_hs__nor2b_1_7.B_N sky130_fd_sc_hs__nor2b_1_7.B_N.n4 6.59444
R3165 sky130_fd_sc_hs__nor2b_1_7.B_N.n4 sky130_fd_sc_hs__nor2b_1_7.B_N.n3 212.81
R3166 sky130_fd_sc_hs__nor2b_1_7.B_N.n3 sky130_fd_sc_hs__nor2b_1_7.B_N.t3 128.288
R3167 sky130_fd_sc_hs__nor2b_1_7.B_N.n3 sky130_fd_sc_hs__nor2b_1_7.B_N.t4 219.846
R3168 a_10501_n945.t0 a_10501_n945.n0 35.1791
R3169 a_10501_n945.n0 a_10501_n945.t1 26.3844
R3170 a_10501_n945.n0 a_10501_n945.t2 690.256
R3171 a_10304_n921.t0 a_10304_n921.t1 53.1905
R3172 a_8571_n1177.n1 a_8571_n1177.t0 21.7331
R3173 a_8571_n1177.n0 a_8571_n1177.n1 19.2005
R3174 a_8571_n1177.n1 a_8571_n1177.t1 58.1616
R3175 a_8115_n1226.t0 a_8115_n1226.t1 38.9194
R3176 a_9261_n945.t0 a_9261_n945.n0 690.256
R3177 a_9261_n945.n0 a_9261_n945.t1 35.1791
R3178 a_9261_n945.n0 a_9261_n945.t2 26.3844
R3179 a_9064_n921.t0 a_9064_n921.t1 53.1905
R3180 a_7325_n1177.n1 a_7325_n1177.t0 21.7331
R3181 a_7325_n1177.n0 a_7325_n1177.n1 19.2005
R3182 a_7325_n1177.n1 a_7325_n1177.t1 58.1616
R3183 a_6869_n1226.t0 a_6869_n1226.t1 38.9194
R3184 a_8015_n945.t0 a_8015_n945.n0 35.1791
R3185 a_8015_n945.n0 a_8015_n945.t2 26.3844
R3186 a_8015_n945.n0 a_8015_n945.t1 690.256
R3187 a_7818_n921.t0 a_7818_n921.t1 53.1905
R3188 a_6077_n1177.n0 a_6077_n1177.n1 19.2005
R3189 a_6077_n1177.n1 a_6077_n1177.t0 21.7331
R3190 a_6077_n1177.n1 a_6077_n1177.t1 58.1616
R3191 a_5623_n1226.t0 a_5623_n1226.t1 38.9194
R3192 a_6769_n945.n0 a_6769_n945.t1 35.1791
R3193 a_6769_n945.t0 a_6769_n945.n0 26.3844
R3194 a_6769_n945.n0 a_6769_n945.t2 690.256
R3195 a_6572_n921.t0 a_6572_n921.t1 53.1905
R3196 a_4833_n1177.n1 a_4833_n1177.t0 21.7331
R3197 a_4833_n1177.n0 a_4833_n1177.n1 19.2005
R3198 a_4833_n1177.n1 a_4833_n1177.t1 58.1616
R3199 a_4377_n1226.t0 a_4377_n1226.t1 38.9194
R3200 a_5523_n945.n0 a_5523_n945.t1 35.1791
R3201 a_5523_n945.t0 a_5523_n945.n0 26.3844
R3202 a_5523_n945.n0 a_5523_n945.t2 690.256
R3203 a_5326_n921.t0 a_5326_n921.t1 53.1905
R3204 a_3589_n1177.n0 a_3589_n1177.n1 19.2005
R3205 a_3589_n1177.n1 a_3589_n1177.t0 21.7331
R3206 a_3589_n1177.n1 a_3589_n1177.t1 58.1616
R3207 a_3133_n1226.t0 a_3133_n1226.t1 38.9194
R3208 a_4277_n945.n0 a_4277_n945.t1 35.1791
R3209 a_4277_n945.t0 a_4277_n945.n0 26.3844
R3210 a_4277_n945.n0 a_4277_n945.t2 690.256
R3211 a_4080_n921.t0 a_4080_n921.t1 53.1905
R3212 a_2341_n1177.n0 a_2341_n1177.n1 19.2005
R3213 a_2341_n1177.n1 a_2341_n1177.t0 21.7331
R3214 a_2341_n1177.n1 a_2341_n1177.t1 58.1616
R3215 a_1887_n1226.t0 a_1887_n1226.t1 38.9194
R3216 a_3033_n945.n0 a_3033_n945.t1 35.1791
R3217 a_3033_n945.t0 a_3033_n945.n0 26.3844
R3218 a_3033_n945.n0 a_3033_n945.t2 690.256
R3219 a_2836_n921.t0 a_2836_n921.t1 53.1905
R3220 a_1787_n945.t0 a_1787_n945.n0 35.1791
R3221 a_1787_n945.n0 a_1787_n945.t1 26.3844
R3222 a_1787_n945.n0 a_1787_n945.t2 690.256
R3223 a_1590_n921.t0 a_1590_n921.t1 53.1905
R3224 a_11879_n1239.t1 a_11879_n1239.n4 172.839
R3225 a_11879_n1239.n1 a_11879_n1239.n0 152
R3226 a_11879_n1239.n4 a_11879_n1239.n1 9.46137
R3227 a_11879_n1239.n4 a_11879_n1239.n3 303.166
R3228 a_11879_n1239.n3 a_11879_n1239.t2 449.469
R3229 a_11879_n1239.t2 a_11879_n1239.t4 733.712
R3230 a_11879_n1239.n3 a_11879_n1239.n2 236.078
R3231 a_11879_n1239.n2 a_11879_n1239.t3 315.515
R3232 a_11879_n1239.n2 a_11879_n1239.t6 209.476
R3233 a_11879_n1239.n1 a_11879_n1239.t0 290.298
R3234 a_11879_n1239.n0 a_11879_n1239.t5 174.898
R3235 a_11879_n1239.n0 a_11879_n1239.t7 282.276
R3236 a_11399_n1201.t1 a_11399_n1201.n1 276.375
R3237 a_11399_n1201.n1 a_11399_n1201.n0 234.287
R3238 a_11399_n1201.n0 a_11399_n1201.t2 210.474
R3239 a_11399_n1201.n0 a_11399_n1201.t3 258.942
R3240 a_11399_n1201.n1 a_11399_n1201.t0 409.457
R3241 a_10950_n1177.t0 a_10950_n1177.n1 266.307
R3242 a_10950_n1177.n1 a_10950_n1177.n2 310.726
R3243 a_10950_n1177.n2 a_10950_n1177.t1 46.9053
R3244 a_10950_n1177.n2 a_10950_n1177.t2 35.1791
R3245 a_10950_n1177.n1 a_10950_n1177.n0 206.288
R3246 a_10950_n1177.n0 a_10950_n1177.t3 178.34
R3247 a_10950_n1177.n0 a_10950_n1177.t4 250.909
R3248 a_10340_n1188.t1 a_10340_n1188.n0 62.3121
R3249 a_10340_n1188.n0 a_10340_n1188.t2 64.7431
R3250 a_10340_n1188.n0 a_10340_n1188.n2 152.939
R3251 a_10340_n1188.n2 a_10340_n1188.t0 230.556
R3252 a_10340_n1188.n2 a_10340_n1188.n1 299.346
R3253 a_10340_n1188.n1 a_10340_n1188.t3 189.588
R3254 a_10340_n1188.n1 a_10340_n1188.t4 258.942
R3255 sky130_fd_sc_hs__and2_1_7.B.n0 sky130_fd_sc_hs__and2_1_7.B.t1 279.738
R3256 sky130_fd_sc_hs__and2_1_7.B.t1 sky130_fd_sc_hs__and2_1_7.B.n8 279.738
R3257 sky130_fd_sc_hs__and2_1_7.B sky130_fd_sc_hs__and2_1_7.B.n0 1.6005
R3258 sky130_fd_sc_hs__and2_1_7.B.n0 sky130_fd_sc_hs__and2_1_7.B.n1 3.2005
R3259 sky130_fd_sc_hs__and2_1_7.B.n1 sky130_fd_sc_hs__and2_1_7.B 8.35606
R3260 sky130_fd_sc_hs__and2_1_7.B sky130_fd_sc_hs__and2_1_7.B.n8 4.44494
R3261 sky130_fd_sc_hs__and2_1_7.B.t0 sky130_fd_sc_hs__and2_1_7.B.n8 305.339
R3262 sky130_fd_sc_hs__and2_1_7.B.n4 sky130_fd_sc_hs__and2_1_7.B.n3 9.3005
R3263 sky130_fd_sc_hs__and2_1_7.B.n1 sky130_fd_sc_hs__and2_1_7.B.n4 20.1391
R3264 sky130_fd_sc_hs__and2_1_7.B.n7 sky130_fd_sc_hs__and2_1_7.B.n6 152
R3265 sky130_fd_sc_hs__and2_1_7.B.n5 sky130_fd_sc_hs__and2_1_7.B 194.862
R3266 sky130_fd_sc_hs__and2_1_7.B sky130_fd_sc_hs__and2_1_7.B.n7 4.84898
R3267 sky130_fd_sc_hs__and2_1_7.B.n4 sky130_fd_sc_hs__and2_1_7.B.n7 10.7893
R3268 sky130_fd_sc_hs__and2_1_7.B sky130_fd_sc_hs__and2_1_7.B.n7 18.824
R3269 sky130_fd_sc_hs__and2_1_7.B.n6 sky130_fd_sc_hs__and2_1_7.B.t3 199.227
R3270 sky130_fd_sc_hs__and2_1_7.B.n6 sky130_fd_sc_hs__and2_1_7.B.t6 250.909
R3271 sky130_fd_sc_hs__and2_1_7.B.t4 sky130_fd_sc_hs__and2_1_7.B.n5 184.476
R3272 sky130_fd_sc_hs__and2_1_7.B.n5 sky130_fd_sc_hs__and2_1_7.B.t7 272.087
R3273 sky130_fd_sc_hs__and2_1_7.B sky130_fd_sc_hs__and2_1_7.B.n3 10.8611
R3274 sky130_fd_sc_hs__and2_1_7.B.n3 sky130_fd_sc_hs__and2_1_7.B.n2 152.97
R3275 sky130_fd_sc_hs__and2_1_7.B.n2 sky130_fd_sc_hs__and2_1_7.B.t2 162.274
R3276 sky130_fd_sc_hs__and2_1_7.B.n2 sky130_fd_sc_hs__and2_1_7.B.t5 280.899
R3277 sky130_fd_sc_hs__and2_1_6.X.n0 sky130_fd_sc_hs__and2_1_6.X.t1 279.738
R3278 sky130_fd_sc_hs__and2_1_6.X.t1 sky130_fd_sc_hs__and2_1_6.X.n9 258.685
R3279 sky130_fd_sc_hs__and2_1_6.X.n0 sky130_fd_sc_hs__and2_1_6.X.n1 12.5817
R3280 sky130_fd_sc_hs__and2_1_6.X.n9 sky130_fd_sc_hs__and2_1_6.X.n0 10.7794
R3281 sky130_fd_sc_hs__and2_1_6.X.n6 sky130_fd_sc_hs__and2_1_6.X.n7 585
R3282 sky130_fd_sc_hs__and2_1_6.X.n7 sky130_fd_sc_hs__and2_1_6.X.n8 585
R3283 sky130_fd_sc_hs__and2_1_6.X sky130_fd_sc_hs__and2_1_6.X.n9 57.326
R3284 sky130_fd_sc_hs__and2_1_6.X sky130_fd_sc_hs__and2_1_6.X.n6 2.10683
R3285 sky130_fd_sc_hs__and2_1_6.X.n6 sky130_fd_sc_hs__and2_1_6.X 9.88404
R3286 sky130_fd_sc_hs__and2_1_6.X sky130_fd_sc_hs__and2_1_6.X.n8 3.07898
R3287 sky130_fd_sc_hs__and2_1_6.X.n8 sky130_fd_sc_hs__and2_1_6.X 8.91189
R3288 sky130_fd_sc_hs__and2_1_6.X sky130_fd_sc_hs__and2_1_6.X.n7 589.052
R3289 sky130_fd_sc_hs__and2_1_6.X.n7 sky130_fd_sc_hs__and2_1_6.X.t0 26.3844
R3290 sky130_fd_sc_hs__and2_1_6.X.n1 sky130_fd_sc_hs__and2_1_6.X.n5 11.2595
R3291 sky130_fd_sc_hs__and2_1_6.X sky130_fd_sc_hs__and2_1_6.X.n5 2.93062
R3292 sky130_fd_sc_hs__and2_1_6.X.n5 sky130_fd_sc_hs__and2_1_6.X.n4 6.42531
R3293 sky130_fd_sc_hs__and2_1_6.X.n4 sky130_fd_sc_hs__and2_1_6.X 5.14939
R3294 sky130_fd_sc_hs__and2_1_6.X.n4 sky130_fd_sc_hs__and2_1_6.X.t2 226.732
R3295 sky130_fd_sc_hs__and2_1_6.X.t2 sky130_fd_sc_hs__and2_1_6.X.t5 446.654
R3296 sky130_fd_sc_hs__and2_1_6.X.n1 sky130_fd_sc_hs__and2_1_6.X.n2 22.89
R3297 sky130_fd_sc_hs__and2_1_6.X sky130_fd_sc_hs__and2_1_6.X.n2 8.93268
R3298 sky130_fd_sc_hs__and2_1_6.X.n2 sky130_fd_sc_hs__and2_1_6.X.n3 97.4339
R3299 sky130_fd_sc_hs__and2_1_6.X.n3 sky130_fd_sc_hs__and2_1_6.X.t7 260.281
R3300 sky130_fd_sc_hs__and2_1_6.X.n3 sky130_fd_sc_hs__and2_1_6.X.t4 173.228
R3301 sky130_fd_sc_hs__and2_1_6.X.t4 sky130_fd_sc_hs__and2_1_6.X.t3 803.333
R3302 sky130_fd_sc_hs__and2_1_6.X.t3 sky130_fd_sc_hs__and2_1_6.X.t6 484.947
R3303 a_9722_n1177.t2 a_9722_n1177.n1 266.307
R3304 a_9722_n1177.n1 a_9722_n1177.n2 310.726
R3305 a_9722_n1177.n2 a_9722_n1177.t0 46.9053
R3306 a_9722_n1177.n2 a_9722_n1177.t1 35.1791
R3307 a_9722_n1177.n1 a_9722_n1177.n0 206.288
R3308 a_9722_n1177.n0 a_9722_n1177.t3 178.34
R3309 a_9722_n1177.n0 a_9722_n1177.t4 250.909
R3310 a_9100_n1188.n0 a_9100_n1188.t1 62.3121
R3311 a_9100_n1188.t0 a_9100_n1188.n0 64.7431
R3312 a_9100_n1188.n0 a_9100_n1188.n2 152.939
R3313 a_9100_n1188.n2 a_9100_n1188.t2 230.556
R3314 a_9100_n1188.n2 a_9100_n1188.n1 299.346
R3315 a_9100_n1188.n1 a_9100_n1188.t3 189.588
R3316 a_9100_n1188.n1 a_9100_n1188.t4 258.942
R3317 sky130_fd_sc_hs__and2_1_5.X.t0 sky130_fd_sc_hs__and2_1_5.X 194.166
R3318 sky130_fd_sc_hs__and2_1_5.X.n0 sky130_fd_sc_hs__and2_1_5.X.n1 585
R3319 sky130_fd_sc_hs__and2_1_5.X.n1 sky130_fd_sc_hs__and2_1_5.X.n2 585
R3320 sky130_fd_sc_hs__and2_1_5.X sky130_fd_sc_hs__and2_1_5.X.n0 2.10683
R3321 sky130_fd_sc_hs__and2_1_5.X.n0 sky130_fd_sc_hs__and2_1_5.X 9.88404
R3322 sky130_fd_sc_hs__and2_1_5.X sky130_fd_sc_hs__and2_1_5.X.n2 3.07898
R3323 sky130_fd_sc_hs__and2_1_5.X.n2 sky130_fd_sc_hs__and2_1_5.X 8.91189
R3324 sky130_fd_sc_hs__and2_1_5.X sky130_fd_sc_hs__and2_1_5.X.n3 1.78278
R3325 sky130_fd_sc_hs__and2_1_5.X.n1 sky130_fd_sc_hs__and2_1_5.X.n3 587.269
R3326 sky130_fd_sc_hs__and2_1_5.X.n3 sky130_fd_sc_hs__and2_1_5.X.n6 15.1422
R3327 sky130_fd_sc_hs__and2_1_5.X.n6 sky130_fd_sc_hs__and2_1_5.X.n8 17.0028
R3328 sky130_fd_sc_hs__and2_1_5.X sky130_fd_sc_hs__and2_1_5.X.n8 2.46797
R3329 sky130_fd_sc_hs__and2_1_5.X.n8 sky130_fd_sc_hs__and2_1_5.X.n7 6.88796
R3330 sky130_fd_sc_hs__and2_1_5.X.n7 sky130_fd_sc_hs__and2_1_5.X 5.14939
R3331 sky130_fd_sc_hs__and2_1_5.X.n7 sky130_fd_sc_hs__and2_1_5.X.t2 226.732
R3332 sky130_fd_sc_hs__and2_1_5.X.t2 sky130_fd_sc_hs__and2_1_5.X.t5 446.654
R3333 sky130_fd_sc_hs__and2_1_5.X sky130_fd_sc_hs__and2_1_5.X.n4 8.93268
R3334 sky130_fd_sc_hs__and2_1_5.X.n6 sky130_fd_sc_hs__and2_1_5.X.n4 19.1617
R3335 sky130_fd_sc_hs__and2_1_5.X.n4 sky130_fd_sc_hs__and2_1_5.X.n5 97.4339
R3336 sky130_fd_sc_hs__and2_1_5.X.n5 sky130_fd_sc_hs__and2_1_5.X.t7 260.281
R3337 sky130_fd_sc_hs__and2_1_5.X.n5 sky130_fd_sc_hs__and2_1_5.X.t4 173.228
R3338 sky130_fd_sc_hs__and2_1_5.X.t4 sky130_fd_sc_hs__and2_1_5.X.t3 803.333
R3339 sky130_fd_sc_hs__and2_1_5.X.t3 sky130_fd_sc_hs__and2_1_5.X.t6 484.947
R3340 sky130_fd_sc_hs__and2_1_5.X.n1 sky130_fd_sc_hs__and2_1_5.X.t1 26.3844
R3341 a_8484_n1177.t0 a_8484_n1177.n1 266.307
R3342 a_8484_n1177.n1 a_8484_n1177.n2 310.726
R3343 a_8484_n1177.n2 a_8484_n1177.t1 46.9053
R3344 a_8484_n1177.n2 a_8484_n1177.t2 35.1791
R3345 a_8484_n1177.n1 a_8484_n1177.n0 206.288
R3346 a_8484_n1177.n0 a_8484_n1177.t3 178.34
R3347 a_8484_n1177.n0 a_8484_n1177.t4 250.909
R3348 a_7854_n1188.t0 a_7854_n1188.n0 62.3121
R3349 a_7854_n1188.n0 a_7854_n1188.t1 64.7431
R3350 a_7854_n1188.n0 a_7854_n1188.n2 152.939
R3351 a_7854_n1188.n2 a_7854_n1188.t2 230.556
R3352 a_7854_n1188.n2 a_7854_n1188.n1 299.346
R3353 a_7854_n1188.n1 a_7854_n1188.t3 189.588
R3354 a_7854_n1188.n1 a_7854_n1188.t4 258.942
R3355 sky130_fd_sc_hs__and2_1_4.X.n0 sky130_fd_sc_hs__and2_1_4.X.t1 279.738
R3356 sky130_fd_sc_hs__and2_1_4.X.t1 sky130_fd_sc_hs__and2_1_4.X.n9 258.685
R3357 sky130_fd_sc_hs__and2_1_4.X.n0 sky130_fd_sc_hs__and2_1_4.X.n5 11.0708
R3358 sky130_fd_sc_hs__and2_1_4.X.n9 sky130_fd_sc_hs__and2_1_4.X.n0 10.7794
R3359 sky130_fd_sc_hs__and2_1_4.X.n6 sky130_fd_sc_hs__and2_1_4.X.n7 585
R3360 sky130_fd_sc_hs__and2_1_4.X.n7 sky130_fd_sc_hs__and2_1_4.X.n8 585
R3361 sky130_fd_sc_hs__and2_1_4.X sky130_fd_sc_hs__and2_1_4.X.n9 57.326
R3362 sky130_fd_sc_hs__and2_1_4.X sky130_fd_sc_hs__and2_1_4.X.n6 2.10683
R3363 sky130_fd_sc_hs__and2_1_4.X.n6 sky130_fd_sc_hs__and2_1_4.X 9.88404
R3364 sky130_fd_sc_hs__and2_1_4.X sky130_fd_sc_hs__and2_1_4.X.n8 3.07898
R3365 sky130_fd_sc_hs__and2_1_4.X.n8 sky130_fd_sc_hs__and2_1_4.X 8.91189
R3366 sky130_fd_sc_hs__and2_1_4.X sky130_fd_sc_hs__and2_1_4.X.n7 589.052
R3367 sky130_fd_sc_hs__and2_1_4.X.n7 sky130_fd_sc_hs__and2_1_4.X.t0 26.3844
R3368 sky130_fd_sc_hs__and2_1_4.X sky130_fd_sc_hs__and2_1_4.X.n3 8.93268
R3369 sky130_fd_sc_hs__and2_1_4.X.n5 sky130_fd_sc_hs__and2_1_4.X.n3 14.6626
R3370 sky130_fd_sc_hs__and2_1_4.X.n3 sky130_fd_sc_hs__and2_1_4.X.n4 97.4339
R3371 sky130_fd_sc_hs__and2_1_4.X.n4 sky130_fd_sc_hs__and2_1_4.X.t7 260.281
R3372 sky130_fd_sc_hs__and2_1_4.X.n4 sky130_fd_sc_hs__and2_1_4.X.t4 173.228
R3373 sky130_fd_sc_hs__and2_1_4.X.t4 sky130_fd_sc_hs__and2_1_4.X.t3 803.333
R3374 sky130_fd_sc_hs__and2_1_4.X.t3 sky130_fd_sc_hs__and2_1_4.X.t6 484.947
R3375 sky130_fd_sc_hs__and2_1_4.X.n5 sky130_fd_sc_hs__and2_1_4.X.n2 11.8874
R3376 sky130_fd_sc_hs__and2_1_4.X sky130_fd_sc_hs__and2_1_4.X.n2 2.7764
R3377 sky130_fd_sc_hs__and2_1_4.X.n2 sky130_fd_sc_hs__and2_1_4.X.n1 6.57952
R3378 sky130_fd_sc_hs__and2_1_4.X.n1 sky130_fd_sc_hs__and2_1_4.X 5.14939
R3379 sky130_fd_sc_hs__and2_1_4.X.n1 sky130_fd_sc_hs__and2_1_4.X.t2 226.732
R3380 sky130_fd_sc_hs__and2_1_4.X.t2 sky130_fd_sc_hs__and2_1_4.X.t5 446.654
R3381 a_7238_n1177.t0 a_7238_n1177.n1 266.307
R3382 a_7238_n1177.n1 a_7238_n1177.n2 310.726
R3383 a_7238_n1177.n2 a_7238_n1177.t2 46.9053
R3384 a_7238_n1177.n2 a_7238_n1177.t1 35.1791
R3385 a_7238_n1177.n1 a_7238_n1177.n0 206.288
R3386 a_7238_n1177.n0 a_7238_n1177.t3 178.34
R3387 a_7238_n1177.n0 a_7238_n1177.t4 250.909
R3388 a_6608_n1188.t0 a_6608_n1188.n0 62.3121
R3389 a_6608_n1188.n0 a_6608_n1188.t1 64.7431
R3390 a_6608_n1188.n0 a_6608_n1188.n2 152.939
R3391 a_6608_n1188.n2 a_6608_n1188.t2 230.556
R3392 a_6608_n1188.n2 a_6608_n1188.n1 299.346
R3393 a_6608_n1188.n1 a_6608_n1188.t3 189.588
R3394 a_6608_n1188.n1 a_6608_n1188.t4 258.942
R3395 sky130_fd_sc_hs__and2_1_3.X.n0 sky130_fd_sc_hs__and2_1_3.X.t1 279.738
R3396 sky130_fd_sc_hs__and2_1_3.X.t1 sky130_fd_sc_hs__and2_1_3.X.n9 258.685
R3397 sky130_fd_sc_hs__and2_1_3.X.n0 sky130_fd_sc_hs__and2_1_3.X.n5 10.4491
R3398 sky130_fd_sc_hs__and2_1_3.X.n9 sky130_fd_sc_hs__and2_1_3.X.n0 10.7794
R3399 sky130_fd_sc_hs__and2_1_3.X.n6 sky130_fd_sc_hs__and2_1_3.X.n7 585
R3400 sky130_fd_sc_hs__and2_1_3.X.n7 sky130_fd_sc_hs__and2_1_3.X.n8 585
R3401 sky130_fd_sc_hs__and2_1_3.X sky130_fd_sc_hs__and2_1_3.X.n9 57.326
R3402 sky130_fd_sc_hs__and2_1_3.X sky130_fd_sc_hs__and2_1_3.X.n6 2.10683
R3403 sky130_fd_sc_hs__and2_1_3.X.n6 sky130_fd_sc_hs__and2_1_3.X 9.88404
R3404 sky130_fd_sc_hs__and2_1_3.X sky130_fd_sc_hs__and2_1_3.X.n8 3.07898
R3405 sky130_fd_sc_hs__and2_1_3.X.n8 sky130_fd_sc_hs__and2_1_3.X 8.91189
R3406 sky130_fd_sc_hs__and2_1_3.X sky130_fd_sc_hs__and2_1_3.X.n7 589.052
R3407 sky130_fd_sc_hs__and2_1_3.X.n7 sky130_fd_sc_hs__and2_1_3.X.t0 26.3844
R3408 sky130_fd_sc_hs__and2_1_3.X sky130_fd_sc_hs__and2_1_3.X.n3 8.93268
R3409 sky130_fd_sc_hs__and2_1_3.X.n5 sky130_fd_sc_hs__and2_1_3.X.n3 14.0684
R3410 sky130_fd_sc_hs__and2_1_3.X.n3 sky130_fd_sc_hs__and2_1_3.X.n4 97.4339
R3411 sky130_fd_sc_hs__and2_1_3.X.n4 sky130_fd_sc_hs__and2_1_3.X.t7 260.281
R3412 sky130_fd_sc_hs__and2_1_3.X.n4 sky130_fd_sc_hs__and2_1_3.X.t4 173.228
R3413 sky130_fd_sc_hs__and2_1_3.X.t4 sky130_fd_sc_hs__and2_1_3.X.t3 803.333
R3414 sky130_fd_sc_hs__and2_1_3.X.t3 sky130_fd_sc_hs__and2_1_3.X.t6 484.947
R3415 sky130_fd_sc_hs__and2_1_3.X.n5 sky130_fd_sc_hs__and2_1_3.X.n2 11.6754
R3416 sky130_fd_sc_hs__and2_1_3.X sky130_fd_sc_hs__and2_1_3.X.n2 2.62219
R3417 sky130_fd_sc_hs__and2_1_3.X.n2 sky130_fd_sc_hs__and2_1_3.X.n1 6.73374
R3418 sky130_fd_sc_hs__and2_1_3.X.n1 sky130_fd_sc_hs__and2_1_3.X 5.14939
R3419 sky130_fd_sc_hs__and2_1_3.X.n1 sky130_fd_sc_hs__and2_1_3.X.t2 226.732
R3420 sky130_fd_sc_hs__and2_1_3.X.t2 sky130_fd_sc_hs__and2_1_3.X.t5 446.654
R3421 a_5990_n1177.t2 a_5990_n1177.n1 266.307
R3422 a_5990_n1177.n1 a_5990_n1177.n2 310.726
R3423 a_5990_n1177.n2 a_5990_n1177.t0 46.9053
R3424 a_5990_n1177.n2 a_5990_n1177.t1 35.1791
R3425 a_5990_n1177.n1 a_5990_n1177.n0 206.288
R3426 a_5990_n1177.n0 a_5990_n1177.t3 178.34
R3427 a_5990_n1177.n0 a_5990_n1177.t4 250.909
R3428 a_5362_n1188.t0 a_5362_n1188.n0 62.3121
R3429 a_5362_n1188.n0 a_5362_n1188.t1 64.7431
R3430 a_5362_n1188.n0 a_5362_n1188.n2 152.939
R3431 a_5362_n1188.n2 a_5362_n1188.t2 230.556
R3432 a_5362_n1188.n2 a_5362_n1188.n1 299.346
R3433 a_5362_n1188.n1 a_5362_n1188.t3 189.588
R3434 a_5362_n1188.n1 a_5362_n1188.t4 258.942
R3435 sky130_fd_sc_hs__and2_1_2.X.n0 sky130_fd_sc_hs__and2_1_2.X.t1 279.873
R3436 sky130_fd_sc_hs__and2_1_2.X.t1 sky130_fd_sc_hs__and2_1_2.X.n9 258.685
R3437 sky130_fd_sc_hs__and2_1_2.X.n9 sky130_fd_sc_hs__and2_1_2.X.n0 10.6447
R3438 sky130_fd_sc_hs__and2_1_2.X.n6 sky130_fd_sc_hs__and2_1_2.X.n7 585
R3439 sky130_fd_sc_hs__and2_1_2.X.n7 sky130_fd_sc_hs__and2_1_2.X.n8 585
R3440 sky130_fd_sc_hs__and2_1_2.X sky130_fd_sc_hs__and2_1_2.X.n9 57.326
R3441 sky130_fd_sc_hs__and2_1_2.X sky130_fd_sc_hs__and2_1_2.X.n6 2.10683
R3442 sky130_fd_sc_hs__and2_1_2.X.n6 sky130_fd_sc_hs__and2_1_2.X 9.88404
R3443 sky130_fd_sc_hs__and2_1_2.X sky130_fd_sc_hs__and2_1_2.X.n8 3.07898
R3444 sky130_fd_sc_hs__and2_1_2.X.n8 sky130_fd_sc_hs__and2_1_2.X 8.91189
R3445 sky130_fd_sc_hs__and2_1_2.X sky130_fd_sc_hs__and2_1_2.X.n7 589.052
R3446 sky130_fd_sc_hs__and2_1_2.X.n7 sky130_fd_sc_hs__and2_1_2.X.t0 26.3844
R3447 sky130_fd_sc_hs__and2_1_2.X.n0 sky130_fd_sc_hs__and2_1_2.X.n1 9.81593
R3448 sky130_fd_sc_hs__and2_1_2.X.n1 sky130_fd_sc_hs__and2_1_2.X.n2 14.4314
R3449 sky130_fd_sc_hs__and2_1_2.X.n1 sky130_fd_sc_hs__and2_1_2.X.n5 11.678
R3450 sky130_fd_sc_hs__and2_1_2.X sky130_fd_sc_hs__and2_1_2.X.n5 3.08484
R3451 sky130_fd_sc_hs__and2_1_2.X.n5 sky130_fd_sc_hs__and2_1_2.X.n4 6.27109
R3452 sky130_fd_sc_hs__and2_1_2.X.n4 sky130_fd_sc_hs__and2_1_2.X 5.14939
R3453 sky130_fd_sc_hs__and2_1_2.X.n4 sky130_fd_sc_hs__and2_1_2.X.t2 226.732
R3454 sky130_fd_sc_hs__and2_1_2.X.t2 sky130_fd_sc_hs__and2_1_2.X.t5 446.654
R3455 sky130_fd_sc_hs__and2_1_2.X sky130_fd_sc_hs__and2_1_2.X.n2 8.93268
R3456 sky130_fd_sc_hs__and2_1_2.X.n2 sky130_fd_sc_hs__and2_1_2.X.n3 97.4339
R3457 sky130_fd_sc_hs__and2_1_2.X.n3 sky130_fd_sc_hs__and2_1_2.X.t7 260.281
R3458 sky130_fd_sc_hs__and2_1_2.X.n3 sky130_fd_sc_hs__and2_1_2.X.t4 173.228
R3459 sky130_fd_sc_hs__and2_1_2.X.t4 sky130_fd_sc_hs__and2_1_2.X.t3 803.333
R3460 sky130_fd_sc_hs__and2_1_2.X.t3 sky130_fd_sc_hs__and2_1_2.X.t6 484.947
R3461 a_4746_n1177.t0 a_4746_n1177.n1 266.307
R3462 a_4746_n1177.n1 a_4746_n1177.n2 310.726
R3463 a_4746_n1177.n2 a_4746_n1177.t2 46.9053
R3464 a_4746_n1177.n2 a_4746_n1177.t1 35.1791
R3465 a_4746_n1177.n1 a_4746_n1177.n0 206.288
R3466 a_4746_n1177.n0 a_4746_n1177.t3 178.34
R3467 a_4746_n1177.n0 a_4746_n1177.t4 250.909
R3468 a_4116_n1188.n0 a_4116_n1188.t2 62.3121
R3469 a_4116_n1188.t1 a_4116_n1188.n0 64.7431
R3470 a_4116_n1188.n0 a_4116_n1188.n2 152.939
R3471 a_4116_n1188.n2 a_4116_n1188.t0 230.556
R3472 a_4116_n1188.n2 a_4116_n1188.n1 299.346
R3473 a_4116_n1188.n1 a_4116_n1188.t3 189.588
R3474 a_4116_n1188.n1 a_4116_n1188.t4 258.942
R3475 sky130_fd_sc_hs__and2_1_1.X.n0 sky130_fd_sc_hs__and2_1_1.X.t1 279.738
R3476 sky130_fd_sc_hs__and2_1_1.X.t1 sky130_fd_sc_hs__and2_1_1.X.n9 258.685
R3477 sky130_fd_sc_hs__and2_1_1.X.n0 sky130_fd_sc_hs__and2_1_1.X.n5 10.2017
R3478 sky130_fd_sc_hs__and2_1_1.X.n9 sky130_fd_sc_hs__and2_1_1.X.n0 10.7794
R3479 sky130_fd_sc_hs__and2_1_1.X.n6 sky130_fd_sc_hs__and2_1_1.X.n7 585
R3480 sky130_fd_sc_hs__and2_1_1.X.n7 sky130_fd_sc_hs__and2_1_1.X.n8 585
R3481 sky130_fd_sc_hs__and2_1_1.X sky130_fd_sc_hs__and2_1_1.X.n9 57.326
R3482 sky130_fd_sc_hs__and2_1_1.X sky130_fd_sc_hs__and2_1_1.X.n6 2.10683
R3483 sky130_fd_sc_hs__and2_1_1.X.n6 sky130_fd_sc_hs__and2_1_1.X 9.88404
R3484 sky130_fd_sc_hs__and2_1_1.X sky130_fd_sc_hs__and2_1_1.X.n8 3.07898
R3485 sky130_fd_sc_hs__and2_1_1.X.n8 sky130_fd_sc_hs__and2_1_1.X 8.91189
R3486 sky130_fd_sc_hs__and2_1_1.X sky130_fd_sc_hs__and2_1_1.X.n7 589.052
R3487 sky130_fd_sc_hs__and2_1_1.X.n7 sky130_fd_sc_hs__and2_1_1.X.t0 26.3844
R3488 sky130_fd_sc_hs__and2_1_1.X sky130_fd_sc_hs__and2_1_1.X.n3 8.93268
R3489 sky130_fd_sc_hs__and2_1_1.X.n5 sky130_fd_sc_hs__and2_1_1.X.n3 14.1634
R3490 sky130_fd_sc_hs__and2_1_1.X.n3 sky130_fd_sc_hs__and2_1_1.X.n4 97.4339
R3491 sky130_fd_sc_hs__and2_1_1.X.n4 sky130_fd_sc_hs__and2_1_1.X.t7 260.281
R3492 sky130_fd_sc_hs__and2_1_1.X.n4 sky130_fd_sc_hs__and2_1_1.X.t4 173.228
R3493 sky130_fd_sc_hs__and2_1_1.X.t4 sky130_fd_sc_hs__and2_1_1.X.t3 803.333
R3494 sky130_fd_sc_hs__and2_1_1.X.t3 sky130_fd_sc_hs__and2_1_1.X.t6 484.947
R3495 sky130_fd_sc_hs__and2_1_1.X.n5 sky130_fd_sc_hs__and2_1_1.X.n2 11.7125
R3496 sky130_fd_sc_hs__and2_1_1.X sky130_fd_sc_hs__and2_1_1.X.n2 2.46797
R3497 sky130_fd_sc_hs__and2_1_1.X.n2 sky130_fd_sc_hs__and2_1_1.X.n1 6.88796
R3498 sky130_fd_sc_hs__and2_1_1.X.n1 sky130_fd_sc_hs__and2_1_1.X 5.14939
R3499 sky130_fd_sc_hs__and2_1_1.X.n1 sky130_fd_sc_hs__and2_1_1.X.t2 226.732
R3500 sky130_fd_sc_hs__and2_1_1.X.t2 sky130_fd_sc_hs__and2_1_1.X.t5 446.654
R3501 a_3502_n1177.t2 a_3502_n1177.n1 266.307
R3502 a_3502_n1177.n1 a_3502_n1177.n2 310.726
R3503 a_3502_n1177.n2 a_3502_n1177.t0 46.9053
R3504 a_3502_n1177.n2 a_3502_n1177.t1 35.1791
R3505 a_3502_n1177.n1 a_3502_n1177.n0 206.288
R3506 a_3502_n1177.n0 a_3502_n1177.t3 178.34
R3507 a_3502_n1177.n0 a_3502_n1177.t4 250.909
R3508 a_2872_n1188.t1 a_2872_n1188.n0 62.3121
R3509 a_2872_n1188.n0 a_2872_n1188.t2 64.7431
R3510 a_2872_n1188.n0 a_2872_n1188.n2 152.939
R3511 a_2872_n1188.n2 a_2872_n1188.t0 230.556
R3512 a_2872_n1188.n2 a_2872_n1188.n1 299.346
R3513 a_2872_n1188.n1 a_2872_n1188.t3 189.588
R3514 a_2872_n1188.n1 a_2872_n1188.t4 258.942
R3515 sky130_fd_sc_hs__and2_1_0.X.n0 sky130_fd_sc_hs__and2_1_0.X.t1 279.738
R3516 sky130_fd_sc_hs__and2_1_0.X.t1 sky130_fd_sc_hs__and2_1_0.X.n9 258.685
R3517 sky130_fd_sc_hs__and2_1_0.X.n9 sky130_fd_sc_hs__and2_1_0.X.n0 10.7794
R3518 sky130_fd_sc_hs__and2_1_0.X.n6 sky130_fd_sc_hs__and2_1_0.X.n7 585
R3519 sky130_fd_sc_hs__and2_1_0.X.n7 sky130_fd_sc_hs__and2_1_0.X.n8 585
R3520 sky130_fd_sc_hs__and2_1_0.X sky130_fd_sc_hs__and2_1_0.X.n9 57.326
R3521 sky130_fd_sc_hs__and2_1_0.X sky130_fd_sc_hs__and2_1_0.X.n6 2.10683
R3522 sky130_fd_sc_hs__and2_1_0.X.n6 sky130_fd_sc_hs__and2_1_0.X 9.88404
R3523 sky130_fd_sc_hs__and2_1_0.X sky130_fd_sc_hs__and2_1_0.X.n8 3.07898
R3524 sky130_fd_sc_hs__and2_1_0.X.n8 sky130_fd_sc_hs__and2_1_0.X 8.91189
R3525 sky130_fd_sc_hs__and2_1_0.X sky130_fd_sc_hs__and2_1_0.X.n7 589.052
R3526 sky130_fd_sc_hs__and2_1_0.X.n7 sky130_fd_sc_hs__and2_1_0.X.t0 26.3844
R3527 sky130_fd_sc_hs__and2_1_0.X.n0 sky130_fd_sc_hs__and2_1_0.X.n5 9.81379
R3528 sky130_fd_sc_hs__and2_1_0.X sky130_fd_sc_hs__and2_1_0.X.n3 8.93268
R3529 sky130_fd_sc_hs__and2_1_0.X.n5 sky130_fd_sc_hs__and2_1_0.X.n3 14.9992
R3530 sky130_fd_sc_hs__and2_1_0.X.n3 sky130_fd_sc_hs__and2_1_0.X.n4 97.4339
R3531 sky130_fd_sc_hs__and2_1_0.X.n4 sky130_fd_sc_hs__and2_1_0.X.t7 260.281
R3532 sky130_fd_sc_hs__and2_1_0.X.n4 sky130_fd_sc_hs__and2_1_0.X.t4 173.228
R3533 sky130_fd_sc_hs__and2_1_0.X.t4 sky130_fd_sc_hs__and2_1_0.X.t3 803.333
R3534 sky130_fd_sc_hs__and2_1_0.X.t3 sky130_fd_sc_hs__and2_1_0.X.t6 484.947
R3535 sky130_fd_sc_hs__and2_1_0.X.n5 sky130_fd_sc_hs__and2_1_0.X.n2 11.4951
R3536 sky130_fd_sc_hs__and2_1_0.X sky130_fd_sc_hs__and2_1_0.X.n2 2.62219
R3537 sky130_fd_sc_hs__and2_1_0.X.n2 sky130_fd_sc_hs__and2_1_0.X.n1 6.73374
R3538 sky130_fd_sc_hs__and2_1_0.X.n1 sky130_fd_sc_hs__and2_1_0.X 5.14939
R3539 sky130_fd_sc_hs__and2_1_0.X.n1 sky130_fd_sc_hs__and2_1_0.X.t2 226.732
R3540 sky130_fd_sc_hs__and2_1_0.X.t2 sky130_fd_sc_hs__and2_1_0.X.t5 446.654
R3541 a_2254_n1177.t2 a_2254_n1177.n1 266.307
R3542 a_2254_n1177.n1 a_2254_n1177.n2 310.726
R3543 a_2254_n1177.n2 a_2254_n1177.t1 46.9053
R3544 a_2254_n1177.n2 a_2254_n1177.t0 35.1791
R3545 a_2254_n1177.n1 a_2254_n1177.n0 206.288
R3546 a_2254_n1177.n0 a_2254_n1177.t3 178.34
R3547 a_2254_n1177.n0 a_2254_n1177.t4 250.909
R3548 a_1626_n1188.n0 a_1626_n1188.t2 62.3121
R3549 a_1626_n1188.t0 a_1626_n1188.n0 64.7431
R3550 a_1626_n1188.n0 a_1626_n1188.n2 152.939
R3551 a_1626_n1188.n2 a_1626_n1188.t1 230.556
R3552 a_1626_n1188.n2 a_1626_n1188.n1 299.346
R3553 a_1626_n1188.n1 a_1626_n1188.t3 189.588
R3554 a_1626_n1188.n1 a_1626_n1188.t4 258.942
R3555 a_15716_n385.t0 a_15716_n385.t1 75.7148
R3556 a_15279_n408.t0 a_15279_n408.t1 60.0005
R3557 sky130_fd_sc_hs__and2_1_6.B.n0 sky130_fd_sc_hs__and2_1_6.B.t1 279.738
R3558 sky130_fd_sc_hs__and2_1_6.B.t1 sky130_fd_sc_hs__and2_1_6.B.n11 279.738
R3559 sky130_fd_sc_hs__and2_1_6.B sky130_fd_sc_hs__and2_1_6.B.n10 3.37828
R3560 sky130_fd_sc_hs__and2_1_6.B.n10 sky130_fd_sc_hs__and2_1_6.B.n11 1.06717
R3561 sky130_fd_sc_hs__and2_1_6.B sky130_fd_sc_hs__and2_1_6.B.n9 3.15894
R3562 sky130_fd_sc_hs__and2_1_6.B.n9 sky130_fd_sc_hs__and2_1_6.B.n1 6.15115
R3563 sky130_fd_sc_hs__and2_1_6.B.n1 sky130_fd_sc_hs__and2_1_6.B 2.99271
R3564 sky130_fd_sc_hs__and2_1_6.B sky130_fd_sc_hs__and2_1_6.B.n10 3.15894
R3565 sky130_fd_sc_hs__and2_1_6.B sky130_fd_sc_hs__and2_1_6.B.n0 1.6005
R3566 sky130_fd_sc_hs__and2_1_6.B.n0 sky130_fd_sc_hs__and2_1_6.B.n9 1.77828
R3567 sky130_fd_sc_hs__and2_1_6.B.n4 sky130_fd_sc_hs__and2_1_6.B.n1 40.0954
R3568 sky130_fd_sc_hs__and2_1_6.B.n3 sky130_fd_sc_hs__and2_1_6.B.n4 9.3005
R3569 sky130_fd_sc_hs__and2_1_6.B.n8 sky130_fd_sc_hs__and2_1_6.B.n4 10.599
R3570 sky130_fd_sc_hs__and2_1_6.B.n6 sky130_fd_sc_hs__and2_1_6.B.n7 152
R3571 sky130_fd_sc_hs__and2_1_6.B.n5 sky130_fd_sc_hs__and2_1_6.B 194.862
R3572 sky130_fd_sc_hs__and2_1_6.B sky130_fd_sc_hs__and2_1_6.B.n8 4.65505
R3573 sky130_fd_sc_hs__and2_1_6.B.n8 sky130_fd_sc_hs__and2_1_6.B.n7 0.194439
R3574 sky130_fd_sc_hs__and2_1_6.B sky130_fd_sc_hs__and2_1_6.B.n7 18.824
R3575 sky130_fd_sc_hs__and2_1_6.B.t3 sky130_fd_sc_hs__and2_1_6.B.n6 199.227
R3576 sky130_fd_sc_hs__and2_1_6.B.n6 sky130_fd_sc_hs__and2_1_6.B.t6 250.909
R3577 sky130_fd_sc_hs__and2_1_6.B.t4 sky130_fd_sc_hs__and2_1_6.B.n5 184.476
R3578 sky130_fd_sc_hs__and2_1_6.B.n5 sky130_fd_sc_hs__and2_1_6.B.t7 272.087
R3579 sky130_fd_sc_hs__and2_1_6.B sky130_fd_sc_hs__and2_1_6.B.n3 11.6369
R3580 sky130_fd_sc_hs__and2_1_6.B.n3 sky130_fd_sc_hs__and2_1_6.B.n2 152.195
R3581 sky130_fd_sc_hs__and2_1_6.B.t2 sky130_fd_sc_hs__and2_1_6.B.n2 162.274
R3582 sky130_fd_sc_hs__and2_1_6.B.n2 sky130_fd_sc_hs__and2_1_6.B.t5 280.899
R3583 sky130_fd_sc_hs__and2_1_6.B.n11 sky130_fd_sc_hs__and2_1_6.B.t0 305.339
R3584 a_15666_n1.t0 a_15666_n1.t1 222.798
R3585 a_15559_n85.n3 a_15559_n85.t1 34.0065
R3586 a_15559_n85.t2 a_15559_n85.n3 112.572
R3587 a_15559_n85.n3 a_15559_n85.n1 695.769
R3588 a_15559_n85.n1 a_15559_n85.n2 244.236
R3589 a_15559_n85.n2 a_15559_n85.t4 182.481
R3590 a_15559_n85.n2 a_15559_n85.t5 246.456
R3591 a_15559_n85.n1 a_15559_n85.n0 218.673
R3592 a_15559_n85.n0 a_15559_n85.t0 56.4605
R3593 a_15559_n85.n0 a_15559_n85.t3 70.0005
R3594 a_13604_n385.t0 a_13604_n385.t1 75.7148
R3595 a_13167_n408.t0 a_13167_n408.t1 60.0005
R3596 a_15216_n6.t0 a_15216_n6.t1 112.572
R3597 a_15002_n6.n3 a_15002_n6.t0 6.98822
R3598 a_15002_n6.n0 a_15002_n6.n3 74.3401
R3599 a_15002_n6.n3 a_15002_n6.n1 94.0232
R3600 a_15002_n6.n1 a_15002_n6.t1 70.3576
R3601 a_15002_n6.n1 a_15002_n6.n2 918.856
R3602 a_15002_n6.n2 a_15002_n6.t3 72.8576
R3603 a_15002_n6.n2 a_15002_n6.t2 71.2386
R3604 a_15758_n195.t1 a_15758_n195.n1 288.435
R3605 a_15758_n195.n1 a_15758_n195.n0 152
R3606 a_15758_n195.n1 a_15758_n195.n3 36.7273
R3607 a_15758_n195.n3 a_15758_n195.t0 401.988
R3608 a_15758_n195.n3 a_15758_n195.n2 97.1059
R3609 a_15758_n195.n2 a_15758_n195.t3 282.675
R3610 a_15758_n195.n2 a_15758_n195.t5 198.083
R3611 a_15758_n195.n0 a_15758_n195.t2 220.113
R3612 a_15758_n195.n0 a_15758_n195.t4 250.909
R3613 a_15109_n46.t0 a_15109_n46.n3 68.0124
R3614 a_15109_n46.n3 a_15109_n46.t1 157.345
R3615 a_15109_n46.n3 a_15109_n46.n2 589.926
R3616 a_15109_n46.n2 a_15109_n46.n1 300.101
R3617 a_15109_n46.n1 a_15109_n46.t2 43.7148
R3618 a_15109_n46.n1 a_15109_n46.t3 57.7148
R3619 a_15109_n46.n2 a_15109_n46.n0 260.5
R3620 a_15109_n46.n0 a_15109_n46.t5 203.294
R3621 a_15109_n46.n0 a_15109_n46.t4 380.639
R3622 a_15261_n51.n3 a_15261_n51.n2 230.298
R3623 a_15261_n51.t0 a_15261_n51.n3 24.2336
R3624 a_15261_n51.n3 a_15261_n51.t3 49.4918
R3625 a_15261_n51.n2 a_15261_n51.n1 662.327
R3626 a_15261_n51.n1 a_15261_n51.t2 37.5243
R3627 a_15261_n51.n1 a_15261_n51.t1 92.6374
R3628 a_15261_n51.n2 a_15261_n51.n0 177.44
R3629 a_15261_n51.n0 a_15261_n51.t4 139.028
R3630 a_15261_n51.n0 a_15261_n51.t5 478.647
R3631 a_14754_n141.t0 a_14754_n141.n1 258.969
R3632 a_14754_n141.n1 a_14754_n141.n0 152
R3633 a_14754_n141.n2 a_14754_n141.t1 217.333
R3634 a_14754_n141.n1 a_14754_n141.n2 30.1502
R3635 a_14754_n141.n2 a_14754_n141.n3 264.704
R3636 a_14754_n141.n3 a_14754_n141.t4 372.413
R3637 a_14754_n141.n3 a_14754_n141.t2 412.152
R3638 a_14754_n141.n0 a_14754_n141.t3 1132.7
R3639 a_14754_n141.n0 a_14754_n141.t5 541.106
R3640 sky130_fd_sc_hs__dfxtp_1_6.D sky130_fd_sc_hs__dfxtp_1_6.D.n0 190.779
R3641 sky130_fd_sc_hs__dfxtp_1_6.D.n0 sky130_fd_sc_hs__dfxtp_1_6.D.t1 34.8654
R3642 sky130_fd_sc_hs__dfxtp_1_6.D.n0 sky130_fd_sc_hs__dfxtp_1_6.D.t0 22.7032
R3643 sky130_fd_sc_hs__dfxtp_1_6.D.n1 sky130_fd_sc_hs__dfxtp_1_6.D.n2 585
R3644 sky130_fd_sc_hs__dfxtp_1_6.D.n2 sky130_fd_sc_hs__dfxtp_1_6.D.n3 585
R3645 sky130_fd_sc_hs__dfxtp_1_6.D sky130_fd_sc_hs__dfxtp_1_6.D.n1 1.01868
R3646 sky130_fd_sc_hs__dfxtp_1_6.D.n1 sky130_fd_sc_hs__dfxtp_1_6.D.n4 6.54595
R3647 sky130_fd_sc_hs__dfxtp_1_6.D.n4 sky130_fd_sc_hs__dfxtp_1_6.D 3.2005
R3648 sky130_fd_sc_hs__dfxtp_1_6.D sky130_fd_sc_hs__dfxtp_1_6.D.n3 2.32777
R3649 sky130_fd_sc_hs__dfxtp_1_6.D.n3 sky130_fd_sc_hs__dfxtp_1_6.D 8.43686
R3650 sky130_fd_sc_hs__dfxtp_1_6.D sky130_fd_sc_hs__dfxtp_1_6.D.n2 588.636
R3651 sky130_fd_sc_hs__dfxtp_1_6.D.n4 sky130_fd_sc_hs__dfxtp_1_6.D.n6 20.3819
R3652 sky130_fd_sc_hs__dfxtp_1_6.D sky130_fd_sc_hs__dfxtp_1_6.D.n5 2.52682
R3653 sky130_fd_sc_hs__dfxtp_1_6.D.n6 sky130_fd_sc_hs__dfxtp_1_6.D.n5 5.38997
R3654 sky130_fd_sc_hs__dfxtp_1_6.D sky130_fd_sc_hs__dfxtp_1_6.D.n5 3.42907
R3655 sky130_fd_sc_hs__dfxtp_1_6.D.t3 sky130_fd_sc_hs__dfxtp_1_6.D 355.692
R3656 sky130_fd_sc_hs__dfxtp_1_6.D.n6 sky130_fd_sc_hs__dfxtp_1_6.D.t4 285.673
R3657 sky130_fd_sc_hs__dfxtp_1_6.D.n2 sky130_fd_sc_hs__dfxtp_1_6.D.t2 27.2639
R3658 a_14346_n141.t0 a_14346_n141.t1 47.4916
R3659 sky130_fd_sc_hs__xor2_1_6.X.n1 sky130_fd_sc_hs__xor2_1_6.X.n0 185
R3660 sky130_fd_sc_hs__xor2_1_6.X.n0 sky130_fd_sc_hs__xor2_1_6.X.n5 185
R3661 sky130_fd_sc_hs__xor2_1_6.X.t0 sky130_fd_sc_hs__xor2_1_6.X.n0 22.7032
R3662 sky130_fd_sc_hs__xor2_1_6.X.n0 sky130_fd_sc_hs__xor2_1_6.X.t2 45.4059
R3663 sky130_fd_sc_hs__xor2_1_6.X sky130_fd_sc_hs__xor2_1_6.X.n1 3.16454
R3664 sky130_fd_sc_hs__xor2_1_6.X.n1 sky130_fd_sc_hs__xor2_1_6.X 7.47915
R3665 sky130_fd_sc_hs__xor2_1_6.X sky130_fd_sc_hs__xor2_1_6.X.n5 4.17129
R3666 sky130_fd_sc_hs__xor2_1_6.X.n2 sky130_fd_sc_hs__xor2_1_6.X.t1 224.7
R3667 sky130_fd_sc_hs__xor2_1_6.X.n5 sky130_fd_sc_hs__xor2_1_6.X.n2 123.757
R3668 sky130_fd_sc_hs__xor2_1_6.X.n2 sky130_fd_sc_hs__xor2_1_6.X.n4 54.7248
R3669 sky130_fd_sc_hs__xor2_1_6.X sky130_fd_sc_hs__xor2_1_6.X.n4 6.78838
R3670 sky130_fd_sc_hs__xor2_1_6.X.n4 sky130_fd_sc_hs__xor2_1_6.X.n3 212.615
R3671 sky130_fd_sc_hs__xor2_1_6.X.n3 sky130_fd_sc_hs__xor2_1_6.X.t3 128.288
R3672 sky130_fd_sc_hs__xor2_1_6.X.n3 sky130_fd_sc_hs__xor2_1_6.X.t4 219.846
R3673 sky130_fd_sc_hs__xor2_1_5.B.n0 sky130_fd_sc_hs__xor2_1_5.B.t1 279.738
R3674 sky130_fd_sc_hs__xor2_1_5.B.t1 sky130_fd_sc_hs__xor2_1_5.B.n9 279.738
R3675 sky130_fd_sc_hs__xor2_1_5.B sky130_fd_sc_hs__xor2_1_5.B.n0 1.6005
R3676 sky130_fd_sc_hs__xor2_1_5.B sky130_fd_sc_hs__xor2_1_5.B.n0 11.5561
R3677 sky130_fd_sc_hs__xor2_1_5.B sky130_fd_sc_hs__xor2_1_5.B.n9 4.44494
R3678 sky130_fd_sc_hs__xor2_1_5.B.n1 sky130_fd_sc_hs__xor2_1_5.B.t0 216.476
R3679 sky130_fd_sc_hs__xor2_1_5.B.n9 sky130_fd_sc_hs__xor2_1_5.B.n1 88.8645
R3680 sky130_fd_sc_hs__xor2_1_5.B.n1 sky130_fd_sc_hs__xor2_1_5.B.n8 62.1351
R3681 sky130_fd_sc_hs__xor2_1_5.B.n8 sky130_fd_sc_hs__xor2_1_5.B.n2 9.30315
R3682 sky130_fd_sc_hs__xor2_1_5.B.n8 sky130_fd_sc_hs__xor2_1_5.B.n7 10.8454
R3683 sky130_fd_sc_hs__xor2_1_5.B.n6 sky130_fd_sc_hs__xor2_1_5.B.n5 152
R3684 sky130_fd_sc_hs__xor2_1_5.B.n4 sky130_fd_sc_hs__xor2_1_5.B 194.862
R3685 sky130_fd_sc_hs__xor2_1_5.B sky130_fd_sc_hs__xor2_1_5.B.n7 4.65505
R3686 sky130_fd_sc_hs__xor2_1_5.B.n7 sky130_fd_sc_hs__xor2_1_5.B.n6 0.194439
R3687 sky130_fd_sc_hs__xor2_1_5.B sky130_fd_sc_hs__xor2_1_5.B.n6 18.824
R3688 sky130_fd_sc_hs__xor2_1_5.B.n5 sky130_fd_sc_hs__xor2_1_5.B.t3 199.227
R3689 sky130_fd_sc_hs__xor2_1_5.B.n5 sky130_fd_sc_hs__xor2_1_5.B.t6 250.909
R3690 sky130_fd_sc_hs__xor2_1_5.B.t4 sky130_fd_sc_hs__xor2_1_5.B.n4 184.476
R3691 sky130_fd_sc_hs__xor2_1_5.B.n4 sky130_fd_sc_hs__xor2_1_5.B.t7 272.087
R3692 sky130_fd_sc_hs__xor2_1_5.B.n2 sky130_fd_sc_hs__xor2_1_5.B.n3 152
R3693 sky130_fd_sc_hs__xor2_1_5.B sky130_fd_sc_hs__xor2_1_5.B.n2 11.8308
R3694 sky130_fd_sc_hs__xor2_1_5.B.n3 sky130_fd_sc_hs__xor2_1_5.B.t2 162.274
R3695 sky130_fd_sc_hs__xor2_1_5.B.n3 sky130_fd_sc_hs__xor2_1_5.B.t5 280.899
R3696 a_13554_n1.t0 a_13554_n1.t1 222.798
R3697 a_13447_n85.n3 a_13447_n85.t0 34.0065
R3698 a_13447_n85.t1 a_13447_n85.n3 112.572
R3699 a_13447_n85.n3 a_13447_n85.n1 695.769
R3700 a_13447_n85.n1 a_13447_n85.n2 244.236
R3701 a_13447_n85.n2 a_13447_n85.t4 182.481
R3702 a_13447_n85.n2 a_13447_n85.t5 246.456
R3703 a_13447_n85.n1 a_13447_n85.n0 218.673
R3704 a_13447_n85.n0 a_13447_n85.t3 56.4605
R3705 a_13447_n85.n0 a_13447_n85.t2 70.0005
R3706 a_11492_n385.t0 a_11492_n385.t1 75.7148
R3707 a_11055_n408.t0 a_11055_n408.t1 60.0005
R3708 a_13104_n6.t0 a_13104_n6.t1 112.572
R3709 a_12890_n6.n3 a_12890_n6.t0 6.98822
R3710 a_12890_n6.n0 a_12890_n6.n3 74.3401
R3711 a_12890_n6.n3 a_12890_n6.n1 94.0232
R3712 a_12890_n6.n1 a_12890_n6.t1 70.3576
R3713 a_12890_n6.n1 a_12890_n6.n2 918.856
R3714 a_12890_n6.n2 a_12890_n6.t2 72.8576
R3715 a_12890_n6.n2 a_12890_n6.t3 71.2386
R3716 a_14575_n435.t1 a_14575_n435.n4 172.839
R3717 a_14575_n435.n1 a_14575_n435.n0 152
R3718 a_14575_n435.n4 a_14575_n435.n1 9.46137
R3719 a_14575_n435.n4 a_14575_n435.n3 303.166
R3720 a_14575_n435.n3 a_14575_n435.t2 449.469
R3721 a_14575_n435.t2 a_14575_n435.t4 733.712
R3722 a_14575_n435.n3 a_14575_n435.n2 236.078
R3723 a_14575_n435.n2 a_14575_n435.t3 315.515
R3724 a_14575_n435.n2 a_14575_n435.t6 209.476
R3725 a_14575_n435.n1 a_14575_n435.t0 290.298
R3726 a_14575_n435.n0 a_14575_n435.t5 174.898
R3727 a_14575_n435.n0 a_14575_n435.t7 282.276
R3728 a_14095_n397.t1 a_14095_n397.n1 276.375
R3729 a_14095_n397.n1 a_14095_n397.n0 234.287
R3730 a_14095_n397.n0 a_14095_n397.t2 210.474
R3731 a_14095_n397.n0 a_14095_n397.t3 258.942
R3732 a_14095_n397.n1 a_14095_n397.t0 409.457
R3733 a_13646_n195.t1 a_13646_n195.n1 288.435
R3734 a_13646_n195.n1 a_13646_n195.n0 152
R3735 a_13646_n195.n1 a_13646_n195.n3 36.7273
R3736 a_13646_n195.n3 a_13646_n195.t0 401.988
R3737 a_13646_n195.n3 a_13646_n195.n2 97.1059
R3738 a_13646_n195.n2 a_13646_n195.t3 282.675
R3739 a_13646_n195.n2 a_13646_n195.t5 198.083
R3740 a_13646_n195.n0 a_13646_n195.t2 220.113
R3741 a_13646_n195.n0 a_13646_n195.t4 250.909
R3742 a_12997_n46.n0 a_12997_n46.n5 28.8005
R3743 a_12997_n46.n5 a_12997_n46.t0 23.1765
R3744 a_12997_n46.n1 a_12997_n46.t3 43.7148
R3745 a_12997_n46.n5 a_12997_n46.n1 22.0005
R3746 a_12997_n46.n1 a_12997_n46.n3 300.101
R3747 a_12997_n46.n3 a_12997_n46.n4 260.5
R3748 a_12997_n46.n4 a_12997_n46.t5 203.294
R3749 a_12997_n46.n4 a_12997_n46.t4 380.639
R3750 a_12997_n46.n2 a_12997_n46.t2 68.0124
R3751 a_12997_n46.n3 a_12997_n46.n2 589.926
R3752 a_12997_n46.n2 a_12997_n46.t1 157.345
R3753 a_13149_n51.n3 a_13149_n51.n2 230.298
R3754 a_13149_n51.n3 a_13149_n51.t3 24.2336
R3755 a_13149_n51.t2 a_13149_n51.n3 49.4918
R3756 a_13149_n51.n2 a_13149_n51.n1 662.327
R3757 a_13149_n51.n1 a_13149_n51.t1 37.5243
R3758 a_13149_n51.n1 a_13149_n51.t0 92.6374
R3759 a_13149_n51.n2 a_13149_n51.n0 177.44
R3760 a_13149_n51.n0 a_13149_n51.t4 139.028
R3761 a_13149_n51.n0 a_13149_n51.t5 478.647
R3762 a_12642_n141.t1 a_12642_n141.n1 258.969
R3763 a_12642_n141.n1 a_12642_n141.n0 152
R3764 a_12642_n141.n2 a_12642_n141.t0 217.333
R3765 a_12642_n141.n1 a_12642_n141.n2 30.1502
R3766 a_12642_n141.n2 a_12642_n141.n3 264.704
R3767 a_12642_n141.n3 a_12642_n141.t4 372.413
R3768 a_12642_n141.n3 a_12642_n141.t2 412.152
R3769 a_12642_n141.n0 a_12642_n141.t3 1132.7
R3770 a_12642_n141.n0 a_12642_n141.t5 541.106
R3771 sky130_fd_sc_hs__dfxtp_1_5.D sky130_fd_sc_hs__dfxtp_1_5.D.n0 190.779
R3772 sky130_fd_sc_hs__dfxtp_1_5.D.t1 sky130_fd_sc_hs__dfxtp_1_5.D.n0 34.8654
R3773 sky130_fd_sc_hs__dfxtp_1_5.D.n0 sky130_fd_sc_hs__dfxtp_1_5.D.t2 22.7032
R3774 sky130_fd_sc_hs__dfxtp_1_5.D.n1 sky130_fd_sc_hs__dfxtp_1_5.D.n2 585
R3775 sky130_fd_sc_hs__dfxtp_1_5.D.n2 sky130_fd_sc_hs__dfxtp_1_5.D.n3 585
R3776 sky130_fd_sc_hs__dfxtp_1_5.D sky130_fd_sc_hs__dfxtp_1_5.D.n1 1.01868
R3777 sky130_fd_sc_hs__dfxtp_1_5.D.n1 sky130_fd_sc_hs__dfxtp_1_5.D.n4 6.98232
R3778 sky130_fd_sc_hs__dfxtp_1_5.D.n4 sky130_fd_sc_hs__dfxtp_1_5.D 2.76414
R3779 sky130_fd_sc_hs__dfxtp_1_5.D sky130_fd_sc_hs__dfxtp_1_5.D.n3 2.32777
R3780 sky130_fd_sc_hs__dfxtp_1_5.D.n3 sky130_fd_sc_hs__dfxtp_1_5.D 8.43686
R3781 sky130_fd_sc_hs__dfxtp_1_5.D sky130_fd_sc_hs__dfxtp_1_5.D.n2 588.636
R3782 sky130_fd_sc_hs__dfxtp_1_5.D sky130_fd_sc_hs__dfxtp_1_5.D.n6 2.52682
R3783 sky130_fd_sc_hs__dfxtp_1_5.D.n5 sky130_fd_sc_hs__dfxtp_1_5.D.n6 5.55839
R3784 sky130_fd_sc_hs__dfxtp_1_5.D.n4 sky130_fd_sc_hs__dfxtp_1_5.D.n5 23.6585
R3785 sky130_fd_sc_hs__dfxtp_1_5.D sky130_fd_sc_hs__dfxtp_1_5.D.n6 3.42907
R3786 sky130_fd_sc_hs__dfxtp_1_5.D.t3 sky130_fd_sc_hs__dfxtp_1_5.D 355.692
R3787 sky130_fd_sc_hs__dfxtp_1_5.D.n5 sky130_fd_sc_hs__dfxtp_1_5.D.t4 285.505
R3788 sky130_fd_sc_hs__dfxtp_1_5.D.n2 sky130_fd_sc_hs__dfxtp_1_5.D.t0 27.2639
R3789 a_12234_n141.t0 a_12234_n141.t1 47.4916
R3790 sky130_fd_sc_hs__xor2_1_5.X.n1 sky130_fd_sc_hs__xor2_1_5.X.n0 185
R3791 sky130_fd_sc_hs__xor2_1_5.X.n0 sky130_fd_sc_hs__xor2_1_5.X.n5 185
R3792 sky130_fd_sc_hs__xor2_1_5.X.n0 sky130_fd_sc_hs__xor2_1_5.X.t2 22.7032
R3793 sky130_fd_sc_hs__xor2_1_5.X.n0 sky130_fd_sc_hs__xor2_1_5.X.t1 45.4059
R3794 sky130_fd_sc_hs__xor2_1_5.X sky130_fd_sc_hs__xor2_1_5.X.n1 3.16454
R3795 sky130_fd_sc_hs__xor2_1_5.X.n1 sky130_fd_sc_hs__xor2_1_5.X 7.47915
R3796 sky130_fd_sc_hs__xor2_1_5.X sky130_fd_sc_hs__xor2_1_5.X.n5 4.17129
R3797 sky130_fd_sc_hs__xor2_1_5.X.n5 sky130_fd_sc_hs__xor2_1_5.X.n4 51.2688
R3798 sky130_fd_sc_hs__xor2_1_5.X.n4 sky130_fd_sc_hs__xor2_1_5.X.n2 48.8053
R3799 sky130_fd_sc_hs__xor2_1_5.X.n4 sky130_fd_sc_hs__xor2_1_5.X.t0 288.555
R3800 sky130_fd_sc_hs__xor2_1_5.X sky130_fd_sc_hs__xor2_1_5.X.n2 6.78838
R3801 sky130_fd_sc_hs__xor2_1_5.X.n2 sky130_fd_sc_hs__xor2_1_5.X.n3 212.615
R3802 sky130_fd_sc_hs__xor2_1_5.X.n3 sky130_fd_sc_hs__xor2_1_5.X.t3 128.288
R3803 sky130_fd_sc_hs__xor2_1_5.X.n3 sky130_fd_sc_hs__xor2_1_5.X.t4 219.846
R3804 sky130_fd_sc_hs__xor2_1_4.B.n0 sky130_fd_sc_hs__xor2_1_4.B.t1 279.738
R3805 sky130_fd_sc_hs__xor2_1_4.B.t1 sky130_fd_sc_hs__xor2_1_4.B.n8 279.738
R3806 sky130_fd_sc_hs__xor2_1_4.B sky130_fd_sc_hs__xor2_1_4.B.n0 1.6005
R3807 sky130_fd_sc_hs__xor2_1_4.B sky130_fd_sc_hs__xor2_1_4.B.n0 11.5561
R3808 sky130_fd_sc_hs__xor2_1_4.B sky130_fd_sc_hs__xor2_1_4.B.n8 4.44494
R3809 sky130_fd_sc_hs__xor2_1_4.B.n1 sky130_fd_sc_hs__xor2_1_4.B.t0 217.513
R3810 sky130_fd_sc_hs__xor2_1_4.B.n8 sky130_fd_sc_hs__xor2_1_4.B.n1 87.8266
R3811 sky130_fd_sc_hs__xor2_1_4.B.n1 sky130_fd_sc_hs__xor2_1_4.B.n7 52.0325
R3812 sky130_fd_sc_hs__xor2_1_4.B.n7 sky130_fd_sc_hs__xor2_1_4.B.n6 9.70091
R3813 sky130_fd_sc_hs__xor2_1_4.B sky130_fd_sc_hs__xor2_1_4.B.n6 11.6369
R3814 sky130_fd_sc_hs__xor2_1_4.B.n6 sky130_fd_sc_hs__xor2_1_4.B.n5 152.195
R3815 sky130_fd_sc_hs__xor2_1_4.B.n5 sky130_fd_sc_hs__xor2_1_4.B.t2 162.274
R3816 sky130_fd_sc_hs__xor2_1_4.B.n5 sky130_fd_sc_hs__xor2_1_4.B.t5 280.899
R3817 sky130_fd_sc_hs__xor2_1_4.B.n4 sky130_fd_sc_hs__xor2_1_4.B.n3 152
R3818 sky130_fd_sc_hs__xor2_1_4.B.n2 sky130_fd_sc_hs__xor2_1_4.B 194.862
R3819 sky130_fd_sc_hs__xor2_1_4.B sky130_fd_sc_hs__xor2_1_4.B.n4 4.84898
R3820 sky130_fd_sc_hs__xor2_1_4.B.n7 sky130_fd_sc_hs__xor2_1_4.B.n4 11.2533
R3821 sky130_fd_sc_hs__xor2_1_4.B sky130_fd_sc_hs__xor2_1_4.B.n4 18.824
R3822 sky130_fd_sc_hs__xor2_1_4.B.n3 sky130_fd_sc_hs__xor2_1_4.B.t3 199.227
R3823 sky130_fd_sc_hs__xor2_1_4.B.n3 sky130_fd_sc_hs__xor2_1_4.B.t6 250.909
R3824 sky130_fd_sc_hs__xor2_1_4.B.t4 sky130_fd_sc_hs__xor2_1_4.B.n2 184.476
R3825 sky130_fd_sc_hs__xor2_1_4.B.n2 sky130_fd_sc_hs__xor2_1_4.B.t7 272.087
R3826 a_11442_n1.t0 a_11442_n1.t1 222.798
R3827 a_11335_n85.n0 a_11335_n85.t0 56.4605
R3828 a_11335_n85.t2 a_11335_n85.n0 70.0005
R3829 a_11335_n85.n0 a_11335_n85.n2 218.673
R3830 a_11335_n85.n2 a_11335_n85.n3 244.236
R3831 a_11335_n85.n3 a_11335_n85.t4 182.481
R3832 a_11335_n85.n3 a_11335_n85.t5 246.456
R3833 a_11335_n85.n1 a_11335_n85.t1 34.0065
R3834 a_11335_n85.n2 a_11335_n85.n1 695.769
R3835 a_11335_n85.n1 a_11335_n85.t3 112.572
R3836 a_9380_n385.t0 a_9380_n385.t1 75.7148
R3837 a_8943_n408.t0 a_8943_n408.t1 60.0005
R3838 a_10992_n6.t0 a_10992_n6.t1 112.572
R3839 a_10778_n6.n3 a_10778_n6.t0 6.98822
R3840 a_10778_n6.n0 a_10778_n6.n3 74.3401
R3841 a_10778_n6.n3 a_10778_n6.n1 94.0232
R3842 a_10778_n6.n1 a_10778_n6.t2 70.3576
R3843 a_10778_n6.n1 a_10778_n6.n2 918.856
R3844 a_10778_n6.n2 a_10778_n6.t3 72.8576
R3845 a_10778_n6.n2 a_10778_n6.t1 71.2386
R3846 a_12463_n435.t1 a_12463_n435.n4 172.839
R3847 a_12463_n435.n1 a_12463_n435.n0 152
R3848 a_12463_n435.n4 a_12463_n435.n1 9.46137
R3849 a_12463_n435.n4 a_12463_n435.n3 303.166
R3850 a_12463_n435.n3 a_12463_n435.t2 449.469
R3851 a_12463_n435.t2 a_12463_n435.t4 733.712
R3852 a_12463_n435.n3 a_12463_n435.n2 236.078
R3853 a_12463_n435.n2 a_12463_n435.t3 315.515
R3854 a_12463_n435.n2 a_12463_n435.t6 209.476
R3855 a_12463_n435.n1 a_12463_n435.t0 290.298
R3856 a_12463_n435.n0 a_12463_n435.t5 174.898
R3857 a_12463_n435.n0 a_12463_n435.t7 282.276
R3858 a_11983_n397.t1 a_11983_n397.n1 276.375
R3859 a_11983_n397.n1 a_11983_n397.n0 234.287
R3860 a_11983_n397.n0 a_11983_n397.t2 210.474
R3861 a_11983_n397.n0 a_11983_n397.t3 258.942
R3862 a_11983_n397.n1 a_11983_n397.t0 409.457
R3863 a_11534_n195.t1 a_11534_n195.n1 288.435
R3864 a_11534_n195.n1 a_11534_n195.n0 152
R3865 a_11534_n195.n1 a_11534_n195.n3 36.7273
R3866 a_11534_n195.n3 a_11534_n195.t0 401.988
R3867 a_11534_n195.n3 a_11534_n195.n2 97.1059
R3868 a_11534_n195.n2 a_11534_n195.t3 282.675
R3869 a_11534_n195.n2 a_11534_n195.t5 198.083
R3870 a_11534_n195.n0 a_11534_n195.t2 220.113
R3871 a_11534_n195.n0 a_11534_n195.t4 250.909
R3872 a_10885_n46.n0 a_10885_n46.n5 28.8005
R3873 a_10885_n46.n5 a_10885_n46.t0 23.1765
R3874 a_10885_n46.n1 a_10885_n46.t2 43.7148
R3875 a_10885_n46.n5 a_10885_n46.n1 22.0005
R3876 a_10885_n46.n1 a_10885_n46.n3 300.101
R3877 a_10885_n46.n3 a_10885_n46.n4 260.5
R3878 a_10885_n46.n4 a_10885_n46.t5 203.294
R3879 a_10885_n46.n4 a_10885_n46.t4 380.639
R3880 a_10885_n46.n2 a_10885_n46.t1 68.0124
R3881 a_10885_n46.n3 a_10885_n46.n2 589.926
R3882 a_10885_n46.n2 a_10885_n46.t3 157.345
R3883 a_11037_n51.n3 a_11037_n51.n2 230.298
R3884 a_11037_n51.t0 a_11037_n51.n3 24.2336
R3885 a_11037_n51.n3 a_11037_n51.t3 49.4918
R3886 a_11037_n51.n2 a_11037_n51.n1 662.327
R3887 a_11037_n51.n1 a_11037_n51.t2 37.5243
R3888 a_11037_n51.n1 a_11037_n51.t1 92.6374
R3889 a_11037_n51.n2 a_11037_n51.n0 177.44
R3890 a_11037_n51.n0 a_11037_n51.t4 139.028
R3891 a_11037_n51.n0 a_11037_n51.t5 478.647
R3892 a_10530_n141.t0 a_10530_n141.n1 258.969
R3893 a_10530_n141.n1 a_10530_n141.n0 152
R3894 a_10530_n141.n2 a_10530_n141.t1 217.333
R3895 a_10530_n141.n1 a_10530_n141.n2 30.1502
R3896 a_10530_n141.n2 a_10530_n141.n3 264.704
R3897 a_10530_n141.n3 a_10530_n141.t4 372.413
R3898 a_10530_n141.n3 a_10530_n141.t2 412.152
R3899 a_10530_n141.n0 a_10530_n141.t3 1132.7
R3900 a_10530_n141.n0 a_10530_n141.t5 541.106
R3901 sky130_fd_sc_hs__nor2b_1_4.Y sky130_fd_sc_hs__nor2b_1_4.Y.n0 190.779
R3902 sky130_fd_sc_hs__nor2b_1_4.Y.n0 sky130_fd_sc_hs__nor2b_1_4.Y.t1 34.8654
R3903 sky130_fd_sc_hs__nor2b_1_4.Y.n0 sky130_fd_sc_hs__nor2b_1_4.Y.t0 22.7032
R3904 sky130_fd_sc_hs__nor2b_1_4.Y.n1 sky130_fd_sc_hs__nor2b_1_4.Y.n2 585
R3905 sky130_fd_sc_hs__nor2b_1_4.Y.n2 sky130_fd_sc_hs__nor2b_1_4.Y.n3 585
R3906 sky130_fd_sc_hs__nor2b_1_4.Y sky130_fd_sc_hs__nor2b_1_4.Y.n1 1.01868
R3907 sky130_fd_sc_hs__nor2b_1_4.Y.n1 sky130_fd_sc_hs__nor2b_1_4.Y.n4 6.4005
R3908 sky130_fd_sc_hs__nor2b_1_4.Y.n4 sky130_fd_sc_hs__nor2b_1_4.Y 3.34595
R3909 sky130_fd_sc_hs__nor2b_1_4.Y sky130_fd_sc_hs__nor2b_1_4.Y.n3 2.32777
R3910 sky130_fd_sc_hs__nor2b_1_4.Y.n3 sky130_fd_sc_hs__nor2b_1_4.Y 8.43686
R3911 sky130_fd_sc_hs__nor2b_1_4.Y sky130_fd_sc_hs__nor2b_1_4.Y.n2 588.636
R3912 sky130_fd_sc_hs__nor2b_1_4.Y sky130_fd_sc_hs__nor2b_1_4.Y.n6 2.52682
R3913 sky130_fd_sc_hs__nor2b_1_4.Y.n5 sky130_fd_sc_hs__nor2b_1_4.Y.n6 5.55839
R3914 sky130_fd_sc_hs__nor2b_1_4.Y.n4 sky130_fd_sc_hs__nor2b_1_4.Y.n5 20.1978
R3915 sky130_fd_sc_hs__nor2b_1_4.Y sky130_fd_sc_hs__nor2b_1_4.Y.n6 3.42907
R3916 sky130_fd_sc_hs__nor2b_1_4.Y.t3 sky130_fd_sc_hs__nor2b_1_4.Y 355.692
R3917 sky130_fd_sc_hs__nor2b_1_4.Y.n5 sky130_fd_sc_hs__nor2b_1_4.Y.t4 285.505
R3918 sky130_fd_sc_hs__nor2b_1_4.Y.n2 sky130_fd_sc_hs__nor2b_1_4.Y.t2 27.2639
R3919 a_10122_n141.t0 a_10122_n141.t1 47.4916
R3920 sky130_fd_sc_hs__xor2_1_4.X.n1 sky130_fd_sc_hs__xor2_1_4.X.n0 185
R3921 sky130_fd_sc_hs__xor2_1_4.X.n0 sky130_fd_sc_hs__xor2_1_4.X.n5 185
R3922 sky130_fd_sc_hs__xor2_1_4.X.n0 sky130_fd_sc_hs__xor2_1_4.X.t2 22.7032
R3923 sky130_fd_sc_hs__xor2_1_4.X.n0 sky130_fd_sc_hs__xor2_1_4.X.t1 45.4059
R3924 sky130_fd_sc_hs__xor2_1_4.X sky130_fd_sc_hs__xor2_1_4.X.n1 3.16454
R3925 sky130_fd_sc_hs__xor2_1_4.X.n1 sky130_fd_sc_hs__xor2_1_4.X 7.47915
R3926 sky130_fd_sc_hs__xor2_1_4.X sky130_fd_sc_hs__xor2_1_4.X.n5 4.17129
R3927 sky130_fd_sc_hs__xor2_1_4.X.n2 sky130_fd_sc_hs__xor2_1_4.X.t0 224.594
R3928 sky130_fd_sc_hs__xor2_1_4.X.n5 sky130_fd_sc_hs__xor2_1_4.X.n2 123.864
R3929 sky130_fd_sc_hs__xor2_1_4.X.n2 sky130_fd_sc_hs__xor2_1_4.X.n3 57.565
R3930 sky130_fd_sc_hs__xor2_1_4.X sky130_fd_sc_hs__xor2_1_4.X.n3 6.78838
R3931 sky130_fd_sc_hs__xor2_1_4.X.n3 sky130_fd_sc_hs__xor2_1_4.X.n4 212.615
R3932 sky130_fd_sc_hs__xor2_1_4.X.n4 sky130_fd_sc_hs__xor2_1_4.X.t3 128.288
R3933 sky130_fd_sc_hs__xor2_1_4.X.n4 sky130_fd_sc_hs__xor2_1_4.X.t4 219.846
R3934 sky130_fd_sc_hs__and2_1_3.B.n0 sky130_fd_sc_hs__and2_1_3.B.t0 279.738
R3935 sky130_fd_sc_hs__and2_1_3.B.t0 sky130_fd_sc_hs__and2_1_3.B.n8 279.738
R3936 sky130_fd_sc_hs__and2_1_3.B sky130_fd_sc_hs__and2_1_3.B.n0 1.6005
R3937 sky130_fd_sc_hs__and2_1_3.B sky130_fd_sc_hs__and2_1_3.B.n0 11.5561
R3938 sky130_fd_sc_hs__and2_1_3.B sky130_fd_sc_hs__and2_1_3.B.n8 4.44494
R3939 sky130_fd_sc_hs__and2_1_3.B.n1 sky130_fd_sc_hs__and2_1_3.B.t1 226.81
R3940 sky130_fd_sc_hs__and2_1_3.B.n8 sky130_fd_sc_hs__and2_1_3.B.n1 78.5309
R3941 sky130_fd_sc_hs__and2_1_3.B.n1 sky130_fd_sc_hs__and2_1_3.B.n4 39.7135
R3942 sky130_fd_sc_hs__and2_1_3.B.n7 sky130_fd_sc_hs__and2_1_3.B.n6 152
R3943 sky130_fd_sc_hs__and2_1_3.B.n5 sky130_fd_sc_hs__and2_1_3.B 194.862
R3944 sky130_fd_sc_hs__and2_1_3.B sky130_fd_sc_hs__and2_1_3.B.n7 4.84898
R3945 sky130_fd_sc_hs__and2_1_3.B.n4 sky130_fd_sc_hs__and2_1_3.B.n7 10.7319
R3946 sky130_fd_sc_hs__and2_1_3.B sky130_fd_sc_hs__and2_1_3.B.n7 18.824
R3947 sky130_fd_sc_hs__and2_1_3.B.n6 sky130_fd_sc_hs__and2_1_3.B.t3 199.227
R3948 sky130_fd_sc_hs__and2_1_3.B.n6 sky130_fd_sc_hs__and2_1_3.B.t6 250.909
R3949 sky130_fd_sc_hs__and2_1_3.B.t4 sky130_fd_sc_hs__and2_1_3.B.n5 184.476
R3950 sky130_fd_sc_hs__and2_1_3.B.n5 sky130_fd_sc_hs__and2_1_3.B.t7 272.087
R3951 sky130_fd_sc_hs__and2_1_3.B.n3 sky130_fd_sc_hs__and2_1_3.B.n2 152
R3952 sky130_fd_sc_hs__and2_1_3.B sky130_fd_sc_hs__and2_1_3.B.n3 11.8308
R3953 sky130_fd_sc_hs__and2_1_3.B.n4 sky130_fd_sc_hs__and2_1_3.B.n3 9.68838
R3954 sky130_fd_sc_hs__and2_1_3.B.n2 sky130_fd_sc_hs__and2_1_3.B.t2 162.274
R3955 sky130_fd_sc_hs__and2_1_3.B.n2 sky130_fd_sc_hs__and2_1_3.B.t5 280.899
R3956 a_9330_n1.t0 a_9330_n1.t1 222.798
R3957 a_9223_n85.n3 a_9223_n85.t1 34.0065
R3958 a_9223_n85.t0 a_9223_n85.n3 112.572
R3959 a_9223_n85.n3 a_9223_n85.n1 695.769
R3960 a_9223_n85.n1 a_9223_n85.n2 244.236
R3961 a_9223_n85.n2 a_9223_n85.t4 182.481
R3962 a_9223_n85.n2 a_9223_n85.t5 246.456
R3963 a_9223_n85.n1 a_9223_n85.n0 218.673
R3964 a_9223_n85.n0 a_9223_n85.t2 56.4605
R3965 a_9223_n85.n0 a_9223_n85.t3 70.0005
R3966 a_7268_n385.t0 a_7268_n385.t1 75.7148
R3967 a_6831_n408.t0 a_6831_n408.t1 60.0005
R3968 a_8880_n6.t0 a_8880_n6.t1 112.572
R3969 a_8666_n6.t0 a_8666_n6.n1 71.2386
R3970 a_8666_n6.n1 a_8666_n6.t3 72.8576
R3971 a_8666_n6.n1 a_8666_n6.n0 918.856
R3972 a_8666_n6.n0 a_8666_n6.t2 70.3576
R3973 a_8666_n6.n0 a_8666_n6.t1 155
R3974 a_10351_n435.t1 a_10351_n435.n4 172.839
R3975 a_10351_n435.n1 a_10351_n435.n0 152
R3976 a_10351_n435.n4 a_10351_n435.n1 9.46137
R3977 a_10351_n435.n4 a_10351_n435.n3 303.166
R3978 a_10351_n435.n3 a_10351_n435.t2 449.469
R3979 a_10351_n435.t2 a_10351_n435.t4 733.712
R3980 a_10351_n435.n3 a_10351_n435.n2 236.078
R3981 a_10351_n435.n2 a_10351_n435.t3 315.515
R3982 a_10351_n435.n2 a_10351_n435.t6 209.476
R3983 a_10351_n435.n1 a_10351_n435.t0 290.298
R3984 a_10351_n435.n0 a_10351_n435.t5 174.898
R3985 a_10351_n435.n0 a_10351_n435.t7 282.276
R3986 a_9871_n397.t1 a_9871_n397.n1 276.375
R3987 a_9871_n397.n1 a_9871_n397.n0 234.287
R3988 a_9871_n397.n0 a_9871_n397.t2 210.474
R3989 a_9871_n397.n0 a_9871_n397.t3 258.942
R3990 a_9871_n397.n1 a_9871_n397.t0 409.457
R3991 a_9422_n195.t1 a_9422_n195.n1 288.435
R3992 a_9422_n195.n1 a_9422_n195.n0 152
R3993 a_9422_n195.n1 a_9422_n195.n3 36.7273
R3994 a_9422_n195.n3 a_9422_n195.t0 401.988
R3995 a_9422_n195.n3 a_9422_n195.n2 97.1059
R3996 a_9422_n195.n2 a_9422_n195.t3 282.675
R3997 a_9422_n195.n2 a_9422_n195.t5 198.083
R3998 a_9422_n195.n0 a_9422_n195.t2 220.113
R3999 a_9422_n195.n0 a_9422_n195.t4 250.909
R4000 a_8773_n46.n0 a_8773_n46.n5 28.8005
R4001 a_8773_n46.n5 a_8773_n46.t0 23.1765
R4002 a_8773_n46.n1 a_8773_n46.t3 43.7148
R4003 a_8773_n46.n5 a_8773_n46.n1 22.0005
R4004 a_8773_n46.n1 a_8773_n46.n3 300.101
R4005 a_8773_n46.n3 a_8773_n46.n4 260.5
R4006 a_8773_n46.n4 a_8773_n46.t5 203.294
R4007 a_8773_n46.n4 a_8773_n46.t4 380.639
R4008 a_8773_n46.n2 a_8773_n46.t2 68.0124
R4009 a_8773_n46.n3 a_8773_n46.n2 589.926
R4010 a_8773_n46.n2 a_8773_n46.t1 157.345
R4011 a_8925_n51.n3 a_8925_n51.n2 230.298
R4012 a_8925_n51.n3 a_8925_n51.t3 24.2336
R4013 a_8925_n51.t1 a_8925_n51.n3 49.4918
R4014 a_8925_n51.n2 a_8925_n51.n1 662.327
R4015 a_8925_n51.n1 a_8925_n51.t0 37.5243
R4016 a_8925_n51.n1 a_8925_n51.t2 92.6374
R4017 a_8925_n51.n2 a_8925_n51.n0 177.44
R4018 a_8925_n51.n0 a_8925_n51.t4 139.028
R4019 a_8925_n51.n0 a_8925_n51.t5 478.647
R4020 a_8418_n141.t1 a_8418_n141.n1 258.969
R4021 a_8418_n141.n1 a_8418_n141.n0 152
R4022 a_8418_n141.n2 a_8418_n141.t0 217.333
R4023 a_8418_n141.n1 a_8418_n141.n2 30.1502
R4024 a_8418_n141.n2 a_8418_n141.n3 264.704
R4025 a_8418_n141.n3 a_8418_n141.t4 372.413
R4026 a_8418_n141.n3 a_8418_n141.t2 412.152
R4027 a_8418_n141.n0 a_8418_n141.t3 1132.7
R4028 a_8418_n141.n0 a_8418_n141.t5 541.106
R4029 sky130_fd_sc_hs__nor2b_1_3.Y sky130_fd_sc_hs__nor2b_1_3.Y.n0 190.779
R4030 sky130_fd_sc_hs__nor2b_1_3.Y.n0 sky130_fd_sc_hs__nor2b_1_3.Y.t2 34.8654
R4031 sky130_fd_sc_hs__nor2b_1_3.Y.n0 sky130_fd_sc_hs__nor2b_1_3.Y.t1 22.7032
R4032 sky130_fd_sc_hs__nor2b_1_3.Y.n1 sky130_fd_sc_hs__nor2b_1_3.Y.n2 585
R4033 sky130_fd_sc_hs__nor2b_1_3.Y.n2 sky130_fd_sc_hs__nor2b_1_3.Y.n3 585
R4034 sky130_fd_sc_hs__nor2b_1_3.Y sky130_fd_sc_hs__nor2b_1_3.Y.n1 1.01868
R4035 sky130_fd_sc_hs__nor2b_1_3.Y.n1 sky130_fd_sc_hs__nor2b_1_3.Y.n4 7.27323
R4036 sky130_fd_sc_hs__nor2b_1_3.Y.n4 sky130_fd_sc_hs__nor2b_1_3.Y 2.47323
R4037 sky130_fd_sc_hs__nor2b_1_3.Y sky130_fd_sc_hs__nor2b_1_3.Y.n3 2.32777
R4038 sky130_fd_sc_hs__nor2b_1_3.Y.n3 sky130_fd_sc_hs__nor2b_1_3.Y 8.43686
R4039 sky130_fd_sc_hs__nor2b_1_3.Y sky130_fd_sc_hs__nor2b_1_3.Y.n2 588.636
R4040 sky130_fd_sc_hs__nor2b_1_3.Y sky130_fd_sc_hs__nor2b_1_3.Y.n6 2.52682
R4041 sky130_fd_sc_hs__nor2b_1_3.Y.n5 sky130_fd_sc_hs__nor2b_1_3.Y.n6 5.55839
R4042 sky130_fd_sc_hs__nor2b_1_3.Y.n4 sky130_fd_sc_hs__nor2b_1_3.Y.n5 20.5095
R4043 sky130_fd_sc_hs__nor2b_1_3.Y sky130_fd_sc_hs__nor2b_1_3.Y.n6 3.42907
R4044 sky130_fd_sc_hs__nor2b_1_3.Y.t3 sky130_fd_sc_hs__nor2b_1_3.Y 355.692
R4045 sky130_fd_sc_hs__nor2b_1_3.Y.n5 sky130_fd_sc_hs__nor2b_1_3.Y.t4 285.505
R4046 sky130_fd_sc_hs__nor2b_1_3.Y.n2 sky130_fd_sc_hs__nor2b_1_3.Y.t0 27.2639
R4047 a_8010_n141.t0 a_8010_n141.t1 47.4916
R4048 sky130_fd_sc_hs__xor2_1_3.X.n1 sky130_fd_sc_hs__xor2_1_3.X.n0 185
R4049 sky130_fd_sc_hs__xor2_1_3.X.n0 sky130_fd_sc_hs__xor2_1_3.X.n5 185
R4050 sky130_fd_sc_hs__xor2_1_3.X.t0 sky130_fd_sc_hs__xor2_1_3.X.n0 22.7032
R4051 sky130_fd_sc_hs__xor2_1_3.X.n0 sky130_fd_sc_hs__xor2_1_3.X.t1 45.4059
R4052 sky130_fd_sc_hs__xor2_1_3.X sky130_fd_sc_hs__xor2_1_3.X.n1 3.16454
R4053 sky130_fd_sc_hs__xor2_1_3.X.n1 sky130_fd_sc_hs__xor2_1_3.X 7.47915
R4054 sky130_fd_sc_hs__xor2_1_3.X sky130_fd_sc_hs__xor2_1_3.X.n5 4.17129
R4055 sky130_fd_sc_hs__xor2_1_3.X.n2 sky130_fd_sc_hs__xor2_1_3.X.t2 224.594
R4056 sky130_fd_sc_hs__xor2_1_3.X.n5 sky130_fd_sc_hs__xor2_1_3.X.n2 123.864
R4057 sky130_fd_sc_hs__xor2_1_3.X.n2 sky130_fd_sc_hs__xor2_1_3.X.n4 46.2324
R4058 sky130_fd_sc_hs__xor2_1_3.X sky130_fd_sc_hs__xor2_1_3.X.n4 6.78838
R4059 sky130_fd_sc_hs__xor2_1_3.X.n4 sky130_fd_sc_hs__xor2_1_3.X.n3 212.615
R4060 sky130_fd_sc_hs__xor2_1_3.X.n3 sky130_fd_sc_hs__xor2_1_3.X.t3 128.288
R4061 sky130_fd_sc_hs__xor2_1_3.X.n3 sky130_fd_sc_hs__xor2_1_3.X.t4 219.846
R4062 sky130_fd_sc_hs__and2_1_2.B.n0 sky130_fd_sc_hs__and2_1_2.B.t0 279.738
R4063 sky130_fd_sc_hs__and2_1_2.B.t0 sky130_fd_sc_hs__and2_1_2.B.n8 279.738
R4064 sky130_fd_sc_hs__and2_1_2.B sky130_fd_sc_hs__and2_1_2.B.n0 1.6005
R4065 sky130_fd_sc_hs__and2_1_2.B sky130_fd_sc_hs__and2_1_2.B.n0 11.5561
R4066 sky130_fd_sc_hs__and2_1_2.B sky130_fd_sc_hs__and2_1_2.B.n8 4.44494
R4067 sky130_fd_sc_hs__and2_1_2.B.n1 sky130_fd_sc_hs__and2_1_2.B.t1 216.938
R4068 sky130_fd_sc_hs__and2_1_2.B.n8 sky130_fd_sc_hs__and2_1_2.B.n1 88.4032
R4069 sky130_fd_sc_hs__and2_1_2.B.n1 sky130_fd_sc_hs__and2_1_2.B.n4 40.8846
R4070 sky130_fd_sc_hs__and2_1_2.B.n4 sky130_fd_sc_hs__and2_1_2.B.n3 9.3005
R4071 sky130_fd_sc_hs__and2_1_2.B.n7 sky130_fd_sc_hs__and2_1_2.B.n6 152
R4072 sky130_fd_sc_hs__and2_1_2.B.n5 sky130_fd_sc_hs__and2_1_2.B 194.862
R4073 sky130_fd_sc_hs__and2_1_2.B sky130_fd_sc_hs__and2_1_2.B.n7 4.84898
R4074 sky130_fd_sc_hs__and2_1_2.B.n4 sky130_fd_sc_hs__and2_1_2.B.n7 10.9271
R4075 sky130_fd_sc_hs__and2_1_2.B sky130_fd_sc_hs__and2_1_2.B.n7 18.824
R4076 sky130_fd_sc_hs__and2_1_2.B.n6 sky130_fd_sc_hs__and2_1_2.B.t3 199.227
R4077 sky130_fd_sc_hs__and2_1_2.B.n6 sky130_fd_sc_hs__and2_1_2.B.t6 250.909
R4078 sky130_fd_sc_hs__and2_1_2.B.t4 sky130_fd_sc_hs__and2_1_2.B.n5 184.476
R4079 sky130_fd_sc_hs__and2_1_2.B.n5 sky130_fd_sc_hs__and2_1_2.B.t7 272.087
R4080 sky130_fd_sc_hs__and2_1_2.B sky130_fd_sc_hs__and2_1_2.B.n3 10.6672
R4081 sky130_fd_sc_hs__and2_1_2.B.n3 sky130_fd_sc_hs__and2_1_2.B.n2 153.165
R4082 sky130_fd_sc_hs__and2_1_2.B.n2 sky130_fd_sc_hs__and2_1_2.B.t2 162.274
R4083 sky130_fd_sc_hs__and2_1_2.B.n2 sky130_fd_sc_hs__and2_1_2.B.t5 280.899
R4084 a_7218_n1.t0 a_7218_n1.t1 222.798
R4085 a_7111_n85.n3 a_7111_n85.t1 34.0065
R4086 a_7111_n85.t2 a_7111_n85.n3 112.572
R4087 a_7111_n85.n3 a_7111_n85.n1 695.769
R4088 a_7111_n85.n1 a_7111_n85.n2 244.236
R4089 a_7111_n85.n2 a_7111_n85.t4 182.481
R4090 a_7111_n85.n2 a_7111_n85.t5 246.456
R4091 a_7111_n85.n1 a_7111_n85.n0 218.673
R4092 a_7111_n85.n0 a_7111_n85.t0 56.4605
R4093 a_7111_n85.n0 a_7111_n85.t3 70.0005
R4094 a_5156_n385.t0 a_5156_n385.t1 75.7148
R4095 a_4719_n408.t0 a_4719_n408.t1 60.0005
R4096 a_6768_n6.t0 a_6768_n6.t1 112.572
R4097 a_6554_n6.n3 a_6554_n6.t0 6.98822
R4098 a_6554_n6.n0 a_6554_n6.n3 74.3401
R4099 a_6554_n6.n3 a_6554_n6.n1 94.0232
R4100 a_6554_n6.n1 a_6554_n6.t2 70.3576
R4101 a_6554_n6.n1 a_6554_n6.n2 918.856
R4102 a_6554_n6.n2 a_6554_n6.t3 72.8576
R4103 a_6554_n6.n2 a_6554_n6.t1 71.2386
R4104 a_8239_n435.t1 a_8239_n435.n4 172.839
R4105 a_8239_n435.n1 a_8239_n435.n0 152
R4106 a_8239_n435.n4 a_8239_n435.n1 9.46137
R4107 a_8239_n435.n4 a_8239_n435.n3 303.166
R4108 a_8239_n435.n3 a_8239_n435.t2 449.469
R4109 a_8239_n435.t2 a_8239_n435.t4 733.712
R4110 a_8239_n435.n3 a_8239_n435.n2 236.078
R4111 a_8239_n435.n2 a_8239_n435.t3 315.515
R4112 a_8239_n435.n2 a_8239_n435.t6 209.476
R4113 a_8239_n435.n1 a_8239_n435.t0 290.298
R4114 a_8239_n435.n0 a_8239_n435.t5 174.898
R4115 a_8239_n435.n0 a_8239_n435.t7 282.276
R4116 a_7759_n397.t1 a_7759_n397.n1 276.375
R4117 a_7759_n397.n1 a_7759_n397.n0 234.287
R4118 a_7759_n397.n0 a_7759_n397.t2 210.474
R4119 a_7759_n397.n0 a_7759_n397.t3 258.942
R4120 a_7759_n397.n1 a_7759_n397.t0 409.457
R4121 a_7310_n195.t1 a_7310_n195.n1 288.435
R4122 a_7310_n195.n1 a_7310_n195.n0 152
R4123 a_7310_n195.n1 a_7310_n195.n3 36.7273
R4124 a_7310_n195.n3 a_7310_n195.t0 401.988
R4125 a_7310_n195.n3 a_7310_n195.n2 97.1059
R4126 a_7310_n195.n2 a_7310_n195.t3 282.675
R4127 a_7310_n195.n2 a_7310_n195.t5 198.083
R4128 a_7310_n195.n0 a_7310_n195.t2 220.113
R4129 a_7310_n195.n0 a_7310_n195.t4 250.909
R4130 a_6661_n46.n0 a_6661_n46.n5 28.8005
R4131 a_6661_n46.n5 a_6661_n46.t0 23.1765
R4132 a_6661_n46.n1 a_6661_n46.t2 43.7148
R4133 a_6661_n46.n5 a_6661_n46.n1 22.0005
R4134 a_6661_n46.n1 a_6661_n46.n3 300.101
R4135 a_6661_n46.n3 a_6661_n46.n4 260.5
R4136 a_6661_n46.n4 a_6661_n46.t5 203.294
R4137 a_6661_n46.n4 a_6661_n46.t4 380.639
R4138 a_6661_n46.n2 a_6661_n46.t1 68.0124
R4139 a_6661_n46.n3 a_6661_n46.n2 589.926
R4140 a_6661_n46.n2 a_6661_n46.t3 157.345
R4141 a_6813_n51.n3 a_6813_n51.n2 230.298
R4142 a_6813_n51.t0 a_6813_n51.n3 24.2336
R4143 a_6813_n51.n3 a_6813_n51.t3 49.4918
R4144 a_6813_n51.n2 a_6813_n51.n1 662.327
R4145 a_6813_n51.n1 a_6813_n51.t2 37.5243
R4146 a_6813_n51.n1 a_6813_n51.t1 92.6374
R4147 a_6813_n51.n2 a_6813_n51.n0 177.44
R4148 a_6813_n51.n0 a_6813_n51.t4 139.028
R4149 a_6813_n51.n0 a_6813_n51.t5 478.647
R4150 a_6306_n141.t0 a_6306_n141.n1 258.969
R4151 a_6306_n141.n1 a_6306_n141.n0 152
R4152 a_6306_n141.n2 a_6306_n141.t1 217.333
R4153 a_6306_n141.n1 a_6306_n141.n2 30.1502
R4154 a_6306_n141.n2 a_6306_n141.n3 264.704
R4155 a_6306_n141.n3 a_6306_n141.t4 372.413
R4156 a_6306_n141.n3 a_6306_n141.t2 412.152
R4157 a_6306_n141.n0 a_6306_n141.t3 1132.7
R4158 a_6306_n141.n0 a_6306_n141.t5 541.106
R4159 sky130_fd_sc_hs__dfxtp_1_2.D sky130_fd_sc_hs__dfxtp_1_2.D.n0 190.779
R4160 sky130_fd_sc_hs__dfxtp_1_2.D.n0 sky130_fd_sc_hs__dfxtp_1_2.D.t2 34.8654
R4161 sky130_fd_sc_hs__dfxtp_1_2.D.n0 sky130_fd_sc_hs__dfxtp_1_2.D.t0 22.7032
R4162 sky130_fd_sc_hs__dfxtp_1_2.D.n1 sky130_fd_sc_hs__dfxtp_1_2.D.n2 585
R4163 sky130_fd_sc_hs__dfxtp_1_2.D.n2 sky130_fd_sc_hs__dfxtp_1_2.D.n3 585
R4164 sky130_fd_sc_hs__dfxtp_1_2.D sky130_fd_sc_hs__dfxtp_1_2.D.n1 1.01868
R4165 sky130_fd_sc_hs__dfxtp_1_2.D.n1 sky130_fd_sc_hs__dfxtp_1_2.D.n4 6.83686
R4166 sky130_fd_sc_hs__dfxtp_1_2.D.n4 sky130_fd_sc_hs__dfxtp_1_2.D 2.90959
R4167 sky130_fd_sc_hs__dfxtp_1_2.D sky130_fd_sc_hs__dfxtp_1_2.D.n3 2.32777
R4168 sky130_fd_sc_hs__dfxtp_1_2.D.n3 sky130_fd_sc_hs__dfxtp_1_2.D 8.43686
R4169 sky130_fd_sc_hs__dfxtp_1_2.D sky130_fd_sc_hs__dfxtp_1_2.D.n2 588.636
R4170 sky130_fd_sc_hs__dfxtp_1_2.D sky130_fd_sc_hs__dfxtp_1_2.D.n6 2.52682
R4171 sky130_fd_sc_hs__dfxtp_1_2.D.n5 sky130_fd_sc_hs__dfxtp_1_2.D.n6 5.55839
R4172 sky130_fd_sc_hs__dfxtp_1_2.D.n4 sky130_fd_sc_hs__dfxtp_1_2.D.n5 20.2326
R4173 sky130_fd_sc_hs__dfxtp_1_2.D sky130_fd_sc_hs__dfxtp_1_2.D.n6 3.42907
R4174 sky130_fd_sc_hs__dfxtp_1_2.D.t3 sky130_fd_sc_hs__dfxtp_1_2.D 355.692
R4175 sky130_fd_sc_hs__dfxtp_1_2.D.n5 sky130_fd_sc_hs__dfxtp_1_2.D.t4 285.505
R4176 sky130_fd_sc_hs__dfxtp_1_2.D.n2 sky130_fd_sc_hs__dfxtp_1_2.D.t1 27.2639
R4177 a_5898_n141.t0 a_5898_n141.t1 47.4916
R4178 sky130_fd_sc_hs__xor2_1_2.X.n1 sky130_fd_sc_hs__xor2_1_2.X.n0 185
R4179 sky130_fd_sc_hs__xor2_1_2.X.n0 sky130_fd_sc_hs__xor2_1_2.X.n5 185
R4180 sky130_fd_sc_hs__xor2_1_2.X.t0 sky130_fd_sc_hs__xor2_1_2.X.n0 22.7032
R4181 sky130_fd_sc_hs__xor2_1_2.X.n0 sky130_fd_sc_hs__xor2_1_2.X.t2 45.4059
R4182 sky130_fd_sc_hs__xor2_1_2.X sky130_fd_sc_hs__xor2_1_2.X.n1 3.16454
R4183 sky130_fd_sc_hs__xor2_1_2.X.n1 sky130_fd_sc_hs__xor2_1_2.X 7.47915
R4184 sky130_fd_sc_hs__xor2_1_2.X sky130_fd_sc_hs__xor2_1_2.X.n5 4.17129
R4185 sky130_fd_sc_hs__xor2_1_2.X.n2 sky130_fd_sc_hs__xor2_1_2.X.t1 224.964
R4186 sky130_fd_sc_hs__xor2_1_2.X.n5 sky130_fd_sc_hs__xor2_1_2.X.n2 123.493
R4187 sky130_fd_sc_hs__xor2_1_2.X.n2 sky130_fd_sc_hs__xor2_1_2.X.n4 43.9128
R4188 sky130_fd_sc_hs__xor2_1_2.X sky130_fd_sc_hs__xor2_1_2.X.n4 6.78838
R4189 sky130_fd_sc_hs__xor2_1_2.X.n4 sky130_fd_sc_hs__xor2_1_2.X.n3 212.615
R4190 sky130_fd_sc_hs__xor2_1_2.X.n3 sky130_fd_sc_hs__xor2_1_2.X.t3 128.288
R4191 sky130_fd_sc_hs__xor2_1_2.X.n3 sky130_fd_sc_hs__xor2_1_2.X.t4 219.846
R4192 sky130_fd_sc_hs__xor2_1_1.B.n0 sky130_fd_sc_hs__xor2_1_1.B.t1 279.738
R4193 sky130_fd_sc_hs__xor2_1_1.B.t1 sky130_fd_sc_hs__xor2_1_1.B.n9 279.738
R4194 sky130_fd_sc_hs__xor2_1_1.B sky130_fd_sc_hs__xor2_1_1.B.n0 1.6005
R4195 sky130_fd_sc_hs__xor2_1_1.B.n0 sky130_fd_sc_hs__xor2_1_1.B.n1 7.46717
R4196 sky130_fd_sc_hs__xor2_1_1.B.n1 sky130_fd_sc_hs__xor2_1_1.B 4.08939
R4197 sky130_fd_sc_hs__xor2_1_1.B sky130_fd_sc_hs__xor2_1_1.B.n9 4.44494
R4198 sky130_fd_sc_hs__xor2_1_1.B.t0 sky130_fd_sc_hs__xor2_1_1.B.n9 305.339
R4199 sky130_fd_sc_hs__xor2_1_1.B.n1 sky130_fd_sc_hs__xor2_1_1.B.n2 24.5782
R4200 sky130_fd_sc_hs__xor2_1_1.B.n2 sky130_fd_sc_hs__xor2_1_1.B.n8 10.5918
R4201 sky130_fd_sc_hs__xor2_1_1.B.n7 sky130_fd_sc_hs__xor2_1_1.B.n6 152
R4202 sky130_fd_sc_hs__xor2_1_1.B.n5 sky130_fd_sc_hs__xor2_1_1.B 194.862
R4203 sky130_fd_sc_hs__xor2_1_1.B sky130_fd_sc_hs__xor2_1_1.B.n8 4.46111
R4204 sky130_fd_sc_hs__xor2_1_1.B.n8 sky130_fd_sc_hs__xor2_1_1.B.n7 0.388379
R4205 sky130_fd_sc_hs__xor2_1_1.B sky130_fd_sc_hs__xor2_1_1.B.n7 18.824
R4206 sky130_fd_sc_hs__xor2_1_1.B.n6 sky130_fd_sc_hs__xor2_1_1.B.t3 199.227
R4207 sky130_fd_sc_hs__xor2_1_1.B.n6 sky130_fd_sc_hs__xor2_1_1.B.t6 250.909
R4208 sky130_fd_sc_hs__xor2_1_1.B.t4 sky130_fd_sc_hs__xor2_1_1.B.n5 184.476
R4209 sky130_fd_sc_hs__xor2_1_1.B.n5 sky130_fd_sc_hs__xor2_1_1.B.t7 272.087
R4210 sky130_fd_sc_hs__xor2_1_1.B.n4 sky130_fd_sc_hs__xor2_1_1.B.n3 152
R4211 sky130_fd_sc_hs__xor2_1_1.B sky130_fd_sc_hs__xor2_1_1.B.n4 11.8308
R4212 sky130_fd_sc_hs__xor2_1_1.B.n2 sky130_fd_sc_hs__xor2_1_1.B.n4 9.68838
R4213 sky130_fd_sc_hs__xor2_1_1.B.n3 sky130_fd_sc_hs__xor2_1_1.B.t2 162.274
R4214 sky130_fd_sc_hs__xor2_1_1.B.n3 sky130_fd_sc_hs__xor2_1_1.B.t5 280.899
R4215 a_5106_n1.t0 a_5106_n1.t1 222.798
R4216 a_4999_n85.n3 a_4999_n85.t0 34.0065
R4217 a_4999_n85.t1 a_4999_n85.n3 112.572
R4218 a_4999_n85.n3 a_4999_n85.n1 695.769
R4219 a_4999_n85.n1 a_4999_n85.n2 244.236
R4220 a_4999_n85.n2 a_4999_n85.t4 182.481
R4221 a_4999_n85.n2 a_4999_n85.t5 246.456
R4222 a_4999_n85.n1 a_4999_n85.n0 218.673
R4223 a_4999_n85.n0 a_4999_n85.t3 56.4605
R4224 a_4999_n85.n0 a_4999_n85.t2 70.0005
R4225 a_3044_n385.t0 a_3044_n385.t1 75.7148
R4226 a_2607_n408.t0 a_2607_n408.t1 60.0005
R4227 a_4656_n6.t0 a_4656_n6.t1 112.572
R4228 a_4442_n6.t0 a_4442_n6.n1 72.8576
R4229 a_4442_n6.n1 a_4442_n6.t2 71.2386
R4230 a_4442_n6.n1 a_4442_n6.n0 918.856
R4231 a_4442_n6.n0 a_4442_n6.t3 70.3576
R4232 a_4442_n6.n0 a_4442_n6.t1 155
R4233 a_6127_n435.t1 a_6127_n435.n4 172.839
R4234 a_6127_n435.n1 a_6127_n435.n0 152
R4235 a_6127_n435.n4 a_6127_n435.n1 9.46137
R4236 a_6127_n435.n4 a_6127_n435.n3 303.166
R4237 a_6127_n435.n3 a_6127_n435.t2 449.469
R4238 a_6127_n435.t2 a_6127_n435.t4 733.712
R4239 a_6127_n435.n3 a_6127_n435.n2 236.078
R4240 a_6127_n435.n2 a_6127_n435.t3 315.515
R4241 a_6127_n435.n2 a_6127_n435.t6 209.476
R4242 a_6127_n435.n1 a_6127_n435.t0 290.298
R4243 a_6127_n435.n0 a_6127_n435.t5 174.898
R4244 a_6127_n435.n0 a_6127_n435.t7 282.276
R4245 a_5647_n397.t1 a_5647_n397.n1 276.375
R4246 a_5647_n397.n1 a_5647_n397.n0 234.287
R4247 a_5647_n397.n0 a_5647_n397.t2 210.474
R4248 a_5647_n397.n0 a_5647_n397.t3 258.942
R4249 a_5647_n397.n1 a_5647_n397.t0 409.457
R4250 a_5198_n195.t1 a_5198_n195.n1 288.435
R4251 a_5198_n195.n1 a_5198_n195.n0 152
R4252 a_5198_n195.n1 a_5198_n195.n3 36.7273
R4253 a_5198_n195.n3 a_5198_n195.t0 401.988
R4254 a_5198_n195.n3 a_5198_n195.n2 97.1059
R4255 a_5198_n195.n2 a_5198_n195.t3 282.675
R4256 a_5198_n195.n2 a_5198_n195.t5 198.083
R4257 a_5198_n195.n0 a_5198_n195.t2 220.113
R4258 a_5198_n195.n0 a_5198_n195.t4 250.909
R4259 a_4549_n46.n5 a_4549_n46.t0 23.1765
R4260 a_4549_n46.n0 a_4549_n46.n5 28.8005
R4261 a_4549_n46.n5 a_4549_n46.n1 8.0005
R4262 a_4549_n46.n1 a_4549_n46.t2 57.7148
R4263 a_4549_n46.n1 a_4549_n46.n3 300.101
R4264 a_4549_n46.n3 a_4549_n46.n4 260.5
R4265 a_4549_n46.n4 a_4549_n46.t5 203.294
R4266 a_4549_n46.n4 a_4549_n46.t4 380.639
R4267 a_4549_n46.n2 a_4549_n46.t3 68.0124
R4268 a_4549_n46.n3 a_4549_n46.n2 589.926
R4269 a_4549_n46.n2 a_4549_n46.t1 157.345
R4270 a_4701_n51.n3 a_4701_n51.n2 230.298
R4271 a_4701_n51.n3 a_4701_n51.t3 24.2336
R4272 a_4701_n51.t1 a_4701_n51.n3 49.4918
R4273 a_4701_n51.n2 a_4701_n51.n1 662.327
R4274 a_4701_n51.n1 a_4701_n51.t0 37.5243
R4275 a_4701_n51.n1 a_4701_n51.t2 92.6374
R4276 a_4701_n51.n2 a_4701_n51.n0 177.44
R4277 a_4701_n51.n0 a_4701_n51.t4 139.028
R4278 a_4701_n51.n0 a_4701_n51.t5 478.647
R4279 a_4194_n141.t1 a_4194_n141.n1 258.969
R4280 a_4194_n141.n1 a_4194_n141.n0 152
R4281 a_4194_n141.n2 a_4194_n141.t0 217.333
R4282 a_4194_n141.n1 a_4194_n141.n2 30.1502
R4283 a_4194_n141.n2 a_4194_n141.n3 264.704
R4284 a_4194_n141.n3 a_4194_n141.t4 372.413
R4285 a_4194_n141.n3 a_4194_n141.t2 412.152
R4286 a_4194_n141.n0 a_4194_n141.t3 1132.7
R4287 a_4194_n141.n0 a_4194_n141.t5 541.106
R4288 sky130_fd_sc_hs__dfxtp_1_1.D sky130_fd_sc_hs__dfxtp_1_1.D.n0 190.779
R4289 sky130_fd_sc_hs__dfxtp_1_1.D.n0 sky130_fd_sc_hs__dfxtp_1_1.D.t2 34.8654
R4290 sky130_fd_sc_hs__dfxtp_1_1.D.n0 sky130_fd_sc_hs__dfxtp_1_1.D.t0 22.7032
R4291 sky130_fd_sc_hs__dfxtp_1_1.D.n1 sky130_fd_sc_hs__dfxtp_1_1.D.n2 585
R4292 sky130_fd_sc_hs__dfxtp_1_1.D.n2 sky130_fd_sc_hs__dfxtp_1_1.D.n3 585
R4293 sky130_fd_sc_hs__dfxtp_1_1.D sky130_fd_sc_hs__dfxtp_1_1.D.n1 1.01868
R4294 sky130_fd_sc_hs__dfxtp_1_1.D.n1 sky130_fd_sc_hs__dfxtp_1_1.D.n4 6.4005
R4295 sky130_fd_sc_hs__dfxtp_1_1.D.n4 sky130_fd_sc_hs__dfxtp_1_1.D 3.34595
R4296 sky130_fd_sc_hs__dfxtp_1_1.D sky130_fd_sc_hs__dfxtp_1_1.D.n3 2.32777
R4297 sky130_fd_sc_hs__dfxtp_1_1.D.n3 sky130_fd_sc_hs__dfxtp_1_1.D 8.43686
R4298 sky130_fd_sc_hs__dfxtp_1_1.D sky130_fd_sc_hs__dfxtp_1_1.D.n2 588.636
R4299 sky130_fd_sc_hs__dfxtp_1_1.D.n4 sky130_fd_sc_hs__dfxtp_1_1.D.n6 19.7734
R4300 sky130_fd_sc_hs__dfxtp_1_1.D sky130_fd_sc_hs__dfxtp_1_1.D.n5 2.52682
R4301 sky130_fd_sc_hs__dfxtp_1_1.D.n6 sky130_fd_sc_hs__dfxtp_1_1.D.n5 5.38997
R4302 sky130_fd_sc_hs__dfxtp_1_1.D sky130_fd_sc_hs__dfxtp_1_1.D.n5 3.42907
R4303 sky130_fd_sc_hs__dfxtp_1_1.D.t3 sky130_fd_sc_hs__dfxtp_1_1.D 355.692
R4304 sky130_fd_sc_hs__dfxtp_1_1.D.n6 sky130_fd_sc_hs__dfxtp_1_1.D.t4 285.673
R4305 sky130_fd_sc_hs__dfxtp_1_1.D.n2 sky130_fd_sc_hs__dfxtp_1_1.D.t1 27.2639
R4306 a_3786_n141.t0 a_3786_n141.t1 47.4916
R4307 sky130_fd_sc_hs__xor2_1_1.X.n1 sky130_fd_sc_hs__xor2_1_1.X.n0 185
R4308 sky130_fd_sc_hs__xor2_1_1.X.n0 sky130_fd_sc_hs__xor2_1_1.X.n5 185
R4309 sky130_fd_sc_hs__xor2_1_1.X.t0 sky130_fd_sc_hs__xor2_1_1.X.n0 22.7032
R4310 sky130_fd_sc_hs__xor2_1_1.X.n0 sky130_fd_sc_hs__xor2_1_1.X.t2 45.4059
R4311 sky130_fd_sc_hs__xor2_1_1.X sky130_fd_sc_hs__xor2_1_1.X.n1 3.16454
R4312 sky130_fd_sc_hs__xor2_1_1.X.n1 sky130_fd_sc_hs__xor2_1_1.X 7.47915
R4313 sky130_fd_sc_hs__xor2_1_1.X sky130_fd_sc_hs__xor2_1_1.X.n5 4.17129
R4314 sky130_fd_sc_hs__xor2_1_1.X.n2 sky130_fd_sc_hs__xor2_1_1.X.t1 225.495
R4315 sky130_fd_sc_hs__xor2_1_1.X.n5 sky130_fd_sc_hs__xor2_1_1.X.n2 122.962
R4316 sky130_fd_sc_hs__xor2_1_1.X.n2 sky130_fd_sc_hs__xor2_1_1.X.n4 40.2931
R4317 sky130_fd_sc_hs__xor2_1_1.X sky130_fd_sc_hs__xor2_1_1.X.n4 6.4005
R4318 sky130_fd_sc_hs__xor2_1_1.X.n4 sky130_fd_sc_hs__xor2_1_1.X.n3 213.004
R4319 sky130_fd_sc_hs__xor2_1_1.X.n3 sky130_fd_sc_hs__xor2_1_1.X.t3 128.288
R4320 sky130_fd_sc_hs__xor2_1_1.X.n3 sky130_fd_sc_hs__xor2_1_1.X.t4 219.846
R4321 sky130_fd_sc_hs__and2_1_0.B.n0 sky130_fd_sc_hs__and2_1_0.B.t1 279.738
R4322 sky130_fd_sc_hs__and2_1_0.B.t1 sky130_fd_sc_hs__and2_1_0.B.n9 279.738
R4323 sky130_fd_sc_hs__and2_1_0.B sky130_fd_sc_hs__and2_1_0.B.n0 1.6005
R4324 sky130_fd_sc_hs__and2_1_0.B.n0 sky130_fd_sc_hs__and2_1_0.B.n1 2.84494
R4325 sky130_fd_sc_hs__and2_1_0.B.n1 sky130_fd_sc_hs__and2_1_0.B 8.71161
R4326 sky130_fd_sc_hs__and2_1_0.B sky130_fd_sc_hs__and2_1_0.B.n9 4.44494
R4327 sky130_fd_sc_hs__and2_1_0.B.t0 sky130_fd_sc_hs__and2_1_0.B.n9 305.339
R4328 sky130_fd_sc_hs__and2_1_0.B.n1 sky130_fd_sc_hs__and2_1_0.B.n8 23.4601
R4329 sky130_fd_sc_hs__and2_1_0.B.n8 sky130_fd_sc_hs__and2_1_0.B.n7 9.88629
R4330 sky130_fd_sc_hs__and2_1_0.B sky130_fd_sc_hs__and2_1_0.B.n7 11.249
R4331 sky130_fd_sc_hs__and2_1_0.B.n7 sky130_fd_sc_hs__and2_1_0.B.n6 152.583
R4332 sky130_fd_sc_hs__and2_1_0.B.n6 sky130_fd_sc_hs__and2_1_0.B.t2 162.274
R4333 sky130_fd_sc_hs__and2_1_0.B.n6 sky130_fd_sc_hs__and2_1_0.B.t5 280.899
R4334 sky130_fd_sc_hs__and2_1_0.B.n8 sky130_fd_sc_hs__and2_1_0.B.n5 10.2496
R4335 sky130_fd_sc_hs__and2_1_0.B.n4 sky130_fd_sc_hs__and2_1_0.B.n3 152
R4336 sky130_fd_sc_hs__and2_1_0.B.n2 sky130_fd_sc_hs__and2_1_0.B 194.862
R4337 sky130_fd_sc_hs__and2_1_0.B sky130_fd_sc_hs__and2_1_0.B.n5 4.26717
R4338 sky130_fd_sc_hs__and2_1_0.B.n5 sky130_fd_sc_hs__and2_1_0.B.n4 0.582318
R4339 sky130_fd_sc_hs__and2_1_0.B sky130_fd_sc_hs__and2_1_0.B.n4 18.824
R4340 sky130_fd_sc_hs__and2_1_0.B.n3 sky130_fd_sc_hs__and2_1_0.B.t3 199.227
R4341 sky130_fd_sc_hs__and2_1_0.B.n3 sky130_fd_sc_hs__and2_1_0.B.t6 250.909
R4342 sky130_fd_sc_hs__and2_1_0.B.t4 sky130_fd_sc_hs__and2_1_0.B.n2 184.476
R4343 sky130_fd_sc_hs__and2_1_0.B.n2 sky130_fd_sc_hs__and2_1_0.B.t7 272.087
R4344 a_2994_n1.t0 a_2994_n1.t1 222.798
R4345 a_2887_n85.n3 a_2887_n85.t1 34.0065
R4346 a_2887_n85.t2 a_2887_n85.n3 112.572
R4347 a_2887_n85.n3 a_2887_n85.n1 695.769
R4348 a_2887_n85.n1 a_2887_n85.n2 244.236
R4349 a_2887_n85.n2 a_2887_n85.t4 182.481
R4350 a_2887_n85.n2 a_2887_n85.t5 246.456
R4351 a_2887_n85.n1 a_2887_n85.n0 218.673
R4352 a_2887_n85.n0 a_2887_n85.t0 56.4605
R4353 a_2887_n85.n0 a_2887_n85.t3 70.0005
R4354 a_2544_n6.t0 a_2544_n6.t1 112.572
R4355 a_2330_n6.n3 a_2330_n6.t0 6.98822
R4356 a_2330_n6.n0 a_2330_n6.n3 74.3401
R4357 a_2330_n6.n3 a_2330_n6.n1 94.0232
R4358 a_2330_n6.n1 a_2330_n6.t1 70.3576
R4359 a_2330_n6.n1 a_2330_n6.n2 918.856
R4360 a_2330_n6.n2 a_2330_n6.t2 72.8576
R4361 a_2330_n6.n2 a_2330_n6.t3 71.2386
R4362 a_4015_n435.t1 a_4015_n435.n4 172.839
R4363 a_4015_n435.n1 a_4015_n435.n0 152
R4364 a_4015_n435.n4 a_4015_n435.n1 9.46137
R4365 a_4015_n435.n4 a_4015_n435.n3 303.166
R4366 a_4015_n435.n3 a_4015_n435.t2 449.469
R4367 a_4015_n435.t2 a_4015_n435.t4 733.712
R4368 a_4015_n435.n3 a_4015_n435.n2 236.078
R4369 a_4015_n435.n2 a_4015_n435.t3 315.515
R4370 a_4015_n435.n2 a_4015_n435.t6 209.476
R4371 a_4015_n435.n1 a_4015_n435.t0 290.298
R4372 a_4015_n435.n0 a_4015_n435.t5 174.898
R4373 a_4015_n435.n0 a_4015_n435.t7 282.276
R4374 a_3535_n397.t1 a_3535_n397.n1 276.375
R4375 a_3535_n397.n1 a_3535_n397.n0 234.287
R4376 a_3535_n397.n0 a_3535_n397.t2 210.474
R4377 a_3535_n397.n0 a_3535_n397.t3 258.942
R4378 a_3535_n397.n1 a_3535_n397.t0 409.457
R4379 a_3086_n195.t1 a_3086_n195.n1 288.435
R4380 a_3086_n195.n1 a_3086_n195.n0 152
R4381 a_3086_n195.n1 a_3086_n195.n3 36.7273
R4382 a_3086_n195.n3 a_3086_n195.t0 401.988
R4383 a_3086_n195.n3 a_3086_n195.n2 97.1059
R4384 a_3086_n195.n2 a_3086_n195.t3 282.675
R4385 a_3086_n195.n2 a_3086_n195.t5 198.083
R4386 a_3086_n195.n0 a_3086_n195.t2 220.113
R4387 a_3086_n195.n0 a_3086_n195.t4 250.909
R4388 a_2437_n46.t0 a_2437_n46.n3 68.0124
R4389 a_2437_n46.n3 a_2437_n46.t2 157.345
R4390 a_2437_n46.n3 a_2437_n46.n2 589.926
R4391 a_2437_n46.n2 a_2437_n46.n1 300.101
R4392 a_2437_n46.n1 a_2437_n46.t3 43.7148
R4393 a_2437_n46.n1 a_2437_n46.t1 57.7148
R4394 a_2437_n46.n2 a_2437_n46.n0 260.5
R4395 a_2437_n46.n0 a_2437_n46.t5 203.294
R4396 a_2437_n46.n0 a_2437_n46.t4 380.639
R4397 a_2589_n51.n3 a_2589_n51.n2 230.298
R4398 a_2589_n51.t0 a_2589_n51.n3 24.2336
R4399 a_2589_n51.n3 a_2589_n51.t3 49.4918
R4400 a_2589_n51.n2 a_2589_n51.n1 662.327
R4401 a_2589_n51.n1 a_2589_n51.t2 37.5243
R4402 a_2589_n51.n1 a_2589_n51.t1 92.6374
R4403 a_2589_n51.n2 a_2589_n51.n0 177.44
R4404 a_2589_n51.n0 a_2589_n51.t4 139.028
R4405 a_2589_n51.n0 a_2589_n51.t5 478.647
R4406 a_2082_n141.t0 a_2082_n141.n1 258.969
R4407 a_2082_n141.n1 a_2082_n141.n0 152
R4408 a_2082_n141.n2 a_2082_n141.t1 217.333
R4409 a_2082_n141.n1 a_2082_n141.n2 30.1502
R4410 a_2082_n141.n2 a_2082_n141.n3 264.704
R4411 a_2082_n141.n3 a_2082_n141.t4 372.413
R4412 a_2082_n141.n3 a_2082_n141.t2 412.152
R4413 a_2082_n141.n0 a_2082_n141.t3 1132.7
R4414 a_2082_n141.n0 a_2082_n141.t5 541.106
R4415 sky130_fd_sc_hs__dfxtp_1_8.D sky130_fd_sc_hs__dfxtp_1_8.D.n0 190.779
R4416 sky130_fd_sc_hs__dfxtp_1_8.D.n0 sky130_fd_sc_hs__dfxtp_1_8.D.t1 34.8654
R4417 sky130_fd_sc_hs__dfxtp_1_8.D.n0 sky130_fd_sc_hs__dfxtp_1_8.D.t0 22.7032
R4418 sky130_fd_sc_hs__dfxtp_1_8.D.n1 sky130_fd_sc_hs__dfxtp_1_8.D.n2 585
R4419 sky130_fd_sc_hs__dfxtp_1_8.D.n2 sky130_fd_sc_hs__dfxtp_1_8.D.n3 585
R4420 sky130_fd_sc_hs__dfxtp_1_8.D sky130_fd_sc_hs__dfxtp_1_8.D.n1 1.01868
R4421 sky130_fd_sc_hs__dfxtp_1_8.D.n1 sky130_fd_sc_hs__dfxtp_1_8.D.n4 5.38232
R4422 sky130_fd_sc_hs__dfxtp_1_8.D.n4 sky130_fd_sc_hs__dfxtp_1_8.D 4.36414
R4423 sky130_fd_sc_hs__dfxtp_1_8.D sky130_fd_sc_hs__dfxtp_1_8.D.n3 2.32777
R4424 sky130_fd_sc_hs__dfxtp_1_8.D.n3 sky130_fd_sc_hs__dfxtp_1_8.D 8.43686
R4425 sky130_fd_sc_hs__dfxtp_1_8.D sky130_fd_sc_hs__dfxtp_1_8.D.n2 588.636
R4426 sky130_fd_sc_hs__dfxtp_1_8.D sky130_fd_sc_hs__dfxtp_1_8.D.n6 2.52682
R4427 sky130_fd_sc_hs__dfxtp_1_8.D.n5 sky130_fd_sc_hs__dfxtp_1_8.D.n6 5.55839
R4428 sky130_fd_sc_hs__dfxtp_1_8.D.n4 sky130_fd_sc_hs__dfxtp_1_8.D.n5 20.0909
R4429 sky130_fd_sc_hs__dfxtp_1_8.D sky130_fd_sc_hs__dfxtp_1_8.D.n6 3.42907
R4430 sky130_fd_sc_hs__dfxtp_1_8.D.t3 sky130_fd_sc_hs__dfxtp_1_8.D 355.692
R4431 sky130_fd_sc_hs__dfxtp_1_8.D.n5 sky130_fd_sc_hs__dfxtp_1_8.D.t4 285.505
R4432 sky130_fd_sc_hs__dfxtp_1_8.D.n2 sky130_fd_sc_hs__dfxtp_1_8.D.t2 27.2639
R4433 a_1674_n141.t0 a_1674_n141.t1 47.4916
R4434 sky130_fd_sc_hs__xor2_1_0.X.n0 sky130_fd_sc_hs__xor2_1_0.X.n1 185
R4435 sky130_fd_sc_hs__xor2_1_0.X.n5 sky130_fd_sc_hs__xor2_1_0.X.n0 185
R4436 sky130_fd_sc_hs__xor2_1_0.X.n0 sky130_fd_sc_hs__xor2_1_0.X.t2 22.7032
R4437 sky130_fd_sc_hs__xor2_1_0.X.n0 sky130_fd_sc_hs__xor2_1_0.X.t1 45.4059
R4438 sky130_fd_sc_hs__xor2_1_0.X sky130_fd_sc_hs__xor2_1_0.X.n1 3.16454
R4439 sky130_fd_sc_hs__xor2_1_0.X sky130_fd_sc_hs__xor2_1_0.X.n1 7.47915
R4440 sky130_fd_sc_hs__xor2_1_0.X sky130_fd_sc_hs__xor2_1_0.X.n5 4.17129
R4441 sky130_fd_sc_hs__xor2_1_0.X.n5 sky130_fd_sc_hs__xor2_1_0.X.n2 122.978
R4442 sky130_fd_sc_hs__xor2_1_0.X.n2 sky130_fd_sc_hs__xor2_1_0.X.n4 43.4883
R4443 sky130_fd_sc_hs__xor2_1_0.X sky130_fd_sc_hs__xor2_1_0.X.n4 6.4005
R4444 sky130_fd_sc_hs__xor2_1_0.X.n4 sky130_fd_sc_hs__xor2_1_0.X.n3 213.004
R4445 sky130_fd_sc_hs__xor2_1_0.X.n3 sky130_fd_sc_hs__xor2_1_0.X.t3 128.288
R4446 sky130_fd_sc_hs__xor2_1_0.X.n3 sky130_fd_sc_hs__xor2_1_0.X.t4 219.846
R4447 sky130_fd_sc_hs__xor2_1_0.X.n2 sky130_fd_sc_hs__xor2_1_0.X.t0 225.32
R4448 a_1903_n435.t1 a_1903_n435.n4 172.839
R4449 a_1903_n435.n1 a_1903_n435.n0 152
R4450 a_1903_n435.n4 a_1903_n435.n1 9.46137
R4451 a_1903_n435.n4 a_1903_n435.n3 303.166
R4452 a_1903_n435.n3 a_1903_n435.t2 449.469
R4453 a_1903_n435.t2 a_1903_n435.t4 733.712
R4454 a_1903_n435.n3 a_1903_n435.n2 236.078
R4455 a_1903_n435.n2 a_1903_n435.t3 315.515
R4456 a_1903_n435.n2 a_1903_n435.t6 209.476
R4457 a_1903_n435.n1 a_1903_n435.t0 290.298
R4458 a_1903_n435.n0 a_1903_n435.t5 174.898
R4459 a_1903_n435.n0 a_1903_n435.t7 282.276
R4460 a_1423_n397.t1 a_1423_n397.n1 276.375
R4461 a_1423_n397.n1 a_1423_n397.n0 234.287
R4462 a_1423_n397.n0 a_1423_n397.t2 210.474
R4463 a_1423_n397.n0 a_1423_n397.t3 258.942
R4464 a_1423_n397.n1 a_1423_n397.t0 409.457
R4465 VGND sky130_fd_sc_hs__dfxtp_1_6.VNB 5478.95
C0 sky130_fd_sc_hs__and2_1_0.B VPWR 0.76674f
C1 VPWR sky130_fd_sc_hs__and2_1_1.X 0.50925f
C2 sky130_fd_sc_hs__xor2_1_1.B sky130_fd_sc_hs__xor2_1_4.X 0.00212f
C3 sky130_fd_sc_hs__and2_1_3.B sky130_fd_sc_hs__xor2_1_4.X 0.25138f
C4 sky130_fd_sc_hs__and2_1_7.B VPWR 0.34511f
C5 sky130_fd_sc_hs__xor2_1_5.X sky130_fd_sc_hs__nor2b_1_4.Y 0.12384f
C6 sky130_fd_sc_hs__and2_1_6.X sky130_fd_sc_hs__nor2b_1_4.Y 0.00128f
C7 sky130_fd_sc_hs__xor2_1_5.X sky130_fd_sc_hs__and2_1_2.B 0
C8 clk sky130_fd_sc_hs__and2_1_3.X 0
C9 sky130_fd_sc_hs__nor2b_1_4.Y sky130_fd_sc_hs__nor2b_1_3.Y 0
C10 sky130_fd_sc_hs__nor2b_1_3.Y sky130_fd_sc_hs__and2_1_2.B 0
C11 sky130_fd_sc_hs__and2_1_2.B sky130_fd_sc_hs__dfxtp_1_2.D 0.23455f
C12 sky130_fd_sc_hs__and2_1_0.B sky130_fd_sc_hs__xor2_1_1.X 0.05568f
C13 sky130_fd_sc_hs__xor2_1_1.X sky130_fd_sc_hs__and2_1_1.X 0.0023f
C14 sky130_fd_sc_hs__xor2_1_4.X sky130_fd_sc_hs__and2_1_7.X 0
C15 sky130_fd_sc_hs__xor2_1_5.B sky130_fd_sc_hs__and2_1_5.X 0.49084f
C16 sky130_fd_sc_hs__dfxtp_1_1.D clk 0.13948f
C17 sky130_fd_sc_hs__and2_1_2.B sky130_fd_sc_hs__and2_1_2.X 0.03167f
C18 sky130_fd_sc_hs__dfxtp_1_6.D sky130_fd_sc_hs__dfxtp_1_5.D 0
C19 sky130_fd_sc_hs__xor2_1_4.X sky130_fd_sc_hs__and2_1_4.X 0.00108f
C20 sky130_fd_sc_hs__and2_1_3.B sky130_fd_sc_hs__nor2b_1_4.Y 0.00916f
C21 sky130_fd_sc_hs__dfxtp_1_5.D sky130_fd_sc_hs__nor2b_1_4.Y 0
C22 sky130_fd_sc_hs__xor2_1_1.X VPWR 0.46757f
C23 sky130_fd_sc_hs__xor2_1_1.B sky130_fd_sc_hs__and2_1_2.B 0.19154f
C24 sky130_fd_sc_hs__xor2_1_2.X sky130_fd_sc_hs__xor2_1_4.X 0
C25 sky130_fd_sc_hs__and2_1_3.B sky130_fd_sc_hs__and2_1_2.B 0.01454f
C26 sky130_fd_sc_hs__xor2_1_0.X sky130_fd_sc_hs__xor2_1_1.B 0
C27 sky130_fd_sc_hs__dfxtp_1_6.D sky130_fd_sc_hs__and2_1_7.X 0
C28 clk sky130_fd_sc_hs__and2_1_5.X 0
C29 VPWR sky130_fd_sc_hs__and2_1_3.X 0.42431f
C30 sky130_fd_sc_hs__nor2b_1_4.Y sky130_fd_sc_hs__and2_1_7.X 0.00228f
C31 sky130_fd_sc_hs__and2_1_0.B sky130_fd_sc_hs__dfxtp_1_1.D 0
C32 sky130_fd_sc_hs__dfxtp_1_1.D sky130_fd_sc_hs__and2_1_1.X 0
C33 rst sky130_fd_sc_hs__xor2_1_5.B 0.52187f
C34 sky130_fd_sc_hs__and2_1_5.X sky130_fd_sc_hs__and2_1_6.B 0.26062f
C35 sky130_fd_sc_hs__xor2_1_6.X sky130_fd_sc_hs__and2_1_5.X 0.0487f
C36 sky130_fd_sc_hs__dfxtp_1_1.D VPWR 0.36438f
C37 sky130_fd_sc_hs__and2_1_2.B sky130_fd_sc_hs__and2_1_4.X 0
C38 sky130_fd_sc_hs__xor2_1_5.B sky130_fd_sc_hs__xor2_1_4.B 0.0334f
C39 sky130_fd_sc_hs__dfxtp_1_0.D sky130_fd_sc_hs__and2_1_7.X 0.00168f
C40 sky130_fd_sc_hs__xor2_1_2.X sky130_fd_sc_hs__and2_1_2.B 0.27361f
C41 sky130_fd_sc_hs__and2_1_7.B sky130_fd_sc_hs__and2_1_5.X 0
C42 en sky130_fd_sc_hs__xor2_1_0.X 0.05512f
C43 rst clk 5.30398f
C44 rst sky130_fd_sc_hs__and2_1_6.B 0.27619f
C45 sky130_fd_sc_hs__xor2_1_5.B sky130_fd_sc_hs__xor2_1_3.X 0.00122f
C46 sky130_fd_sc_hs__xor2_1_1.X sky130_fd_sc_hs__dfxtp_1_1.D 0.00302f
C47 VPWR sky130_fd_sc_hs__and2_1_5.X 0.73426f
C48 rst sky130_fd_sc_hs__xor2_1_6.X 0.21075f
C49 clk sky130_fd_sc_hs__xor2_1_4.B 0.16222f
C50 clk sky130_fd_sc_hs__and2_1_0.X 0
C51 sky130_fd_sc_hs__dfxtp_1_0.D sky130_fd_sc_hs__nor2b_1_7.Y 0
C52 sky130_fd_sc_hs__xor2_1_4.B sky130_fd_sc_hs__and2_1_6.B 0
C53 sky130_fd_sc_hs__and2_1_0.B rst 0.00751f
C54 rst sky130_fd_sc_hs__and2_1_1.X 0
C55 rst sky130_fd_sc_hs__and2_1_7.B 0.0051f
C56 sky130_fd_sc_hs__xor2_1_5.B sky130_fd_sc_hs__xor2_1_5.X 0.2892f
C57 en sky130_fd_sc_hs__dfxtp_1_8.D 0
C58 sky130_fd_sc_hs__xor2_1_5.B sky130_fd_sc_hs__and2_1_6.X 0.5852f
C59 clk sky130_fd_sc_hs__xor2_1_3.X 0.01056f
C60 sky130_fd_sc_hs__xor2_1_5.B sky130_fd_sc_hs__nor2b_1_3.Y 0
C61 rst VPWR 6.91015f
C62 sky130_fd_sc_hs__xor2_1_4.X sky130_fd_sc_hs__nor2b_1_4.Y 0.00137f
C63 sky130_fd_sc_hs__and2_1_7.B sky130_fd_sc_hs__xor2_1_4.B 0
C64 sky130_fd_sc_hs__and2_1_5.X sky130_fd_sc_hs__and2_1_3.X 0
C65 sky130_fd_sc_hs__and2_1_0.B sky130_fd_sc_hs__and2_1_0.X 0.02782f
C66 sky130_fd_sc_hs__and2_1_0.X sky130_fd_sc_hs__and2_1_1.X 0.01566f
C67 sky130_fd_sc_hs__xor2_1_4.X sky130_fd_sc_hs__and2_1_2.B 0.03536f
C68 clk sky130_fd_sc_hs__xor2_1_5.X 0.03516f
C69 sky130_fd_sc_hs__xor2_1_5.B sky130_fd_sc_hs__and2_1_3.B 0.3098f
C70 sky130_fd_sc_hs__xor2_1_4.B VPWR 3.41431f
C71 clk sky130_fd_sc_hs__and2_1_6.X 0
C72 sky130_fd_sc_hs__xor2_1_3.X sky130_fd_sc_hs__and2_1_1.X 0
C73 sky130_fd_sc_hs__xor2_1_5.B sky130_fd_sc_hs__dfxtp_1_5.D 0.2394f
C74 sky130_fd_sc_hs__xor2_1_5.X sky130_fd_sc_hs__and2_1_6.B 0
C75 VPWR sky130_fd_sc_hs__and2_1_0.X 0.52486f
C76 sky130_fd_sc_hs__xor2_1_1.X rst 0.08079f
C77 sky130_fd_sc_hs__and2_1_6.X sky130_fd_sc_hs__and2_1_6.B 0.12785f
C78 clk sky130_fd_sc_hs__nor2b_1_3.Y 0.12455f
C79 clk sky130_fd_sc_hs__dfxtp_1_2.D 0.12646f
C80 sky130_fd_sc_hs__xor2_1_6.X sky130_fd_sc_hs__xor2_1_5.X 0
C81 sky130_fd_sc_hs__xor2_1_6.X sky130_fd_sc_hs__and2_1_6.X 0.04864f
C82 sky130_fd_sc_hs__xor2_1_5.B sky130_fd_sc_hs__nor2b_1_7.B_N 0.09405f
C83 sky130_fd_sc_hs__xor2_1_3.X VPWR 0.92416f
C84 clk sky130_fd_sc_hs__and2_1_2.X 0
C85 sky130_fd_sc_hs__xor2_1_5.B sky130_fd_sc_hs__and2_1_7.X 0.27886f
C86 rst sky130_fd_sc_hs__and2_1_3.X 0
C87 sky130_fd_sc_hs__and2_1_7.B sky130_fd_sc_hs__xor2_1_5.X 0
C88 clk sky130_fd_sc_hs__xor2_1_1.B 0.02761f
C89 sky130_fd_sc_hs__xor2_1_1.X sky130_fd_sc_hs__and2_1_0.X 0.06373f
C90 clk sky130_fd_sc_hs__and2_1_3.B 0.01337f
C91 sky130_fd_sc_hs__and2_1_6.X sky130_fd_sc_hs__and2_1_7.B 0.28073f
C92 clk sky130_fd_sc_hs__dfxtp_1_5.D 0.10171f
C93 sky130_fd_sc_hs__xor2_1_5.B sky130_fd_sc_hs__and2_1_4.X 0.31746f
C94 sky130_fd_sc_hs__and2_1_3.B sky130_fd_sc_hs__and2_1_6.B 0.16887f
C95 sky130_fd_sc_hs__dfxtp_1_0.D sky130_fd_sc_hs__dfxtp_1_6.D 0
C96 sky130_fd_sc_hs__dfxtp_1_5.D sky130_fd_sc_hs__and2_1_6.B 0
C97 sky130_fd_sc_hs__dfxtp_1_1.D rst 0.0307f
C98 sky130_fd_sc_hs__xor2_1_4.B sky130_fd_sc_hs__and2_1_3.X 0.35214f
C99 sky130_fd_sc_hs__xor2_1_6.X sky130_fd_sc_hs__and2_1_3.B 0.19737f
C100 sky130_fd_sc_hs__xor2_1_5.X VPWR 0.42721f
C101 sky130_fd_sc_hs__xor2_1_6.X sky130_fd_sc_hs__dfxtp_1_5.D 0.03262f
C102 sky130_fd_sc_hs__and2_1_6.X VPWR 0.42353f
C103 sky130_fd_sc_hs__and2_1_2.X sky130_fd_sc_hs__and2_1_1.X 0.01484f
C104 clk sky130_fd_sc_hs__nor2b_1_7.B_N 0
C105 overflow sky130_fd_sc_hs__dfxtp_1_0.D 0
C106 clk sky130_fd_sc_hs__and2_1_7.X 0.12402f
C107 sky130_fd_sc_hs__nor2b_1_3.Y VPWR 0.22042f
C108 VPWR sky130_fd_sc_hs__dfxtp_1_2.D 0.22323f
C109 sky130_fd_sc_hs__nor2b_1_7.B_N sky130_fd_sc_hs__and2_1_6.B 0.40603f
C110 sky130_fd_sc_hs__and2_1_0.B sky130_fd_sc_hs__xor2_1_1.B 0.01622f
C111 sky130_fd_sc_hs__xor2_1_1.B sky130_fd_sc_hs__and2_1_1.X 0.03728f
C112 sky130_fd_sc_hs__and2_1_3.B sky130_fd_sc_hs__and2_1_1.X 0
C113 sky130_fd_sc_hs__xor2_1_5.B sky130_fd_sc_hs__nor2b_1_7.Y 0.09042f
C114 sky130_fd_sc_hs__and2_1_7.X sky130_fd_sc_hs__and2_1_6.B 0.18235f
C115 sky130_fd_sc_hs__and2_1_7.B sky130_fd_sc_hs__and2_1_3.B 0
C116 sky130_fd_sc_hs__xor2_1_3.X sky130_fd_sc_hs__and2_1_3.X 0.04987f
C117 sky130_fd_sc_hs__xor2_1_6.X sky130_fd_sc_hs__nor2b_1_7.B_N 0.38105f
C118 clk sky130_fd_sc_hs__and2_1_4.X 0
C119 VPWR sky130_fd_sc_hs__and2_1_2.X 0.43097f
C120 sky130_fd_sc_hs__xor2_1_6.X sky130_fd_sc_hs__and2_1_7.X 0.61465f
C121 rst sky130_fd_sc_hs__and2_1_5.X 0
C122 en clk 0
C123 sky130_fd_sc_hs__and2_1_4.X sky130_fd_sc_hs__and2_1_6.B 0
C124 clk sky130_fd_sc_hs__xor2_1_2.X 0.00187f
C125 sky130_fd_sc_hs__xor2_1_1.B VPWR 0.60853f
C126 sky130_fd_sc_hs__and2_1_3.B VPWR 1.31632f
C127 sky130_fd_sc_hs__xor2_1_6.X sky130_fd_sc_hs__and2_1_4.X 0
C128 sky130_fd_sc_hs__and2_1_7.B sky130_fd_sc_hs__nor2b_1_7.B_N 0.0974f
C129 sky130_fd_sc_hs__dfxtp_1_5.D VPWR 0.21993f
C130 sky130_fd_sc_hs__and2_1_7.B sky130_fd_sc_hs__and2_1_7.X 0.18598f
C131 sky130_fd_sc_hs__xor2_1_5.X sky130_fd_sc_hs__and2_1_3.X 0
C132 sky130_fd_sc_hs__xor2_1_0.X sky130_fd_sc_hs__dfxtp_1_8.D 0.0888f
C133 sky130_fd_sc_hs__xor2_1_4.B sky130_fd_sc_hs__and2_1_5.X 0.00382f
C134 clk sky130_fd_sc_hs__nor2b_1_7.Y 0.0799f
C135 sky130_fd_sc_hs__xor2_1_1.X sky130_fd_sc_hs__and2_1_2.X 0
C136 sky130_fd_sc_hs__nor2b_1_7.Y sky130_fd_sc_hs__and2_1_6.B 0.29916f
C137 VPWR sky130_fd_sc_hs__nor2b_1_7.B_N 0.25171f
C138 en sky130_fd_sc_hs__and2_1_0.B 0.34808f
C139 VPWR sky130_fd_sc_hs__and2_1_7.X 0.48882f
C140 sky130_fd_sc_hs__xor2_1_1.X sky130_fd_sc_hs__xor2_1_1.B 0.33757f
C141 sky130_fd_sc_hs__xor2_1_2.X sky130_fd_sc_hs__and2_1_1.X 0.05816f
C142 sky130_fd_sc_hs__xor2_1_6.X sky130_fd_sc_hs__nor2b_1_7.Y 0.28932f
C143 sky130_fd_sc_hs__xor2_1_5.B sky130_fd_sc_hs__xor2_1_4.X 0
C144 sky130_fd_sc_hs__and2_1_2.X sky130_fd_sc_hs__and2_1_3.X 0.01529f
C145 VPWR sky130_fd_sc_hs__and2_1_4.X 0.42659f
C146 sky130_fd_sc_hs__dfxtp_1_1.D sky130_fd_sc_hs__dfxtp_1_2.D 0.00149f
C147 en VPWR 0.33196f
C148 sky130_fd_sc_hs__and2_1_3.B sky130_fd_sc_hs__and2_1_3.X 0.18086f
C149 sky130_fd_sc_hs__xor2_1_2.X VPWR 1.08156f
C150 sky130_fd_sc_hs__and2_1_7.B sky130_fd_sc_hs__nor2b_1_7.Y 0.02053f
C151 rst sky130_fd_sc_hs__xor2_1_4.B 0.44333f
C152 rst sky130_fd_sc_hs__and2_1_0.X 0
C153 sky130_fd_sc_hs__xor2_1_5.X sky130_fd_sc_hs__and2_1_5.X 0.05326f
C154 sky130_fd_sc_hs__and2_1_6.X sky130_fd_sc_hs__and2_1_5.X 0.02632f
C155 VPWR sky130_fd_sc_hs__nor2b_1_7.Y 0.2237f
C156 sky130_fd_sc_hs__dfxtp_1_6.D sky130_fd_sc_hs__xor2_1_5.B 0.00108f
C157 sky130_fd_sc_hs__dfxtp_1_1.D sky130_fd_sc_hs__xor2_1_1.B 0.1137f
C158 clk sky130_fd_sc_hs__xor2_1_4.X 0.0486f
C159 sky130_fd_sc_hs__xor2_1_5.B sky130_fd_sc_hs__nor2b_1_4.Y 0
C160 en sky130_fd_sc_hs__xor2_1_1.X 0
C161 rst sky130_fd_sc_hs__xor2_1_3.X 0.09294f
C162 sky130_fd_sc_hs__xor2_1_1.X sky130_fd_sc_hs__xor2_1_2.X 0.00267f
C163 sky130_fd_sc_hs__xor2_1_4.X sky130_fd_sc_hs__and2_1_6.B 0.00304f
C164 sky130_fd_sc_hs__xor2_1_6.X sky130_fd_sc_hs__xor2_1_4.X 0
C165 sky130_fd_sc_hs__and2_1_4.X sky130_fd_sc_hs__and2_1_3.X 0.0151f
C166 sky130_fd_sc_hs__xor2_1_2.X sky130_fd_sc_hs__and2_1_3.X 0
C167 sky130_fd_sc_hs__xor2_1_4.B sky130_fd_sc_hs__xor2_1_3.X 0.01189f
C168 sky130_fd_sc_hs__and2_1_3.B sky130_fd_sc_hs__and2_1_5.X 0.28895f
C169 clk sky130_fd_sc_hs__dfxtp_1_6.D 0.13629f
C170 rst sky130_fd_sc_hs__xor2_1_5.X 0.18256f
C171 sky130_fd_sc_hs__dfxtp_1_0.D sky130_fd_sc_hs__xor2_1_5.B 0
C172 rst sky130_fd_sc_hs__and2_1_6.X 0.00354f
C173 clk sky130_fd_sc_hs__nor2b_1_4.Y 0.13139f
C174 sky130_fd_sc_hs__dfxtp_1_6.D sky130_fd_sc_hs__and2_1_6.B 0.10764f
C175 overflow clk 0.00403f
C176 rst sky130_fd_sc_hs__nor2b_1_3.Y 0.01825f
C177 sky130_fd_sc_hs__dfxtp_1_1.D sky130_fd_sc_hs__xor2_1_2.X 0
C178 sky130_fd_sc_hs__dfxtp_1_6.D sky130_fd_sc_hs__xor2_1_6.X 0.0013f
C179 rst sky130_fd_sc_hs__dfxtp_1_2.D 0.0287f
C180 clk sky130_fd_sc_hs__and2_1_2.B 0.06477f
C181 sky130_fd_sc_hs__and2_1_5.X sky130_fd_sc_hs__nor2b_1_7.B_N 0
C182 sky130_fd_sc_hs__xor2_1_4.X VPWR 0.36645f
C183 overflow sky130_fd_sc_hs__and2_1_6.B 0
C184 sky130_fd_sc_hs__and2_1_7.X sky130_fd_sc_hs__and2_1_5.X 0
C185 sky130_fd_sc_hs__xor2_1_4.B sky130_fd_sc_hs__xor2_1_5.X 0.2227f
C186 clk sky130_fd_sc_hs__xor2_1_0.X 0.02923f
C187 rst sky130_fd_sc_hs__and2_1_2.X 0
C188 sky130_fd_sc_hs__and2_1_6.X sky130_fd_sc_hs__xor2_1_4.B 0
C189 sky130_fd_sc_hs__and2_1_4.X sky130_fd_sc_hs__and2_1_5.X 0.01356f
C190 sky130_fd_sc_hs__xor2_1_4.B sky130_fd_sc_hs__nor2b_1_3.Y 0.27156f
C191 sky130_fd_sc_hs__xor2_1_4.B sky130_fd_sc_hs__dfxtp_1_2.D 0
C192 clk sky130_fd_sc_hs__dfxtp_1_0.D 0.08293f
C193 rst sky130_fd_sc_hs__xor2_1_1.B 0.04403f
C194 rst sky130_fd_sc_hs__and2_1_3.B 0.0361f
C195 sky130_fd_sc_hs__and2_1_7.B sky130_fd_sc_hs__nor2b_1_4.Y 0
C196 rst sky130_fd_sc_hs__dfxtp_1_5.D 0.05812f
C197 sky130_fd_sc_hs__xor2_1_5.X sky130_fd_sc_hs__xor2_1_3.X 0
C198 sky130_fd_sc_hs__dfxtp_1_0.D sky130_fd_sc_hs__and2_1_6.B 0.236f
C199 sky130_fd_sc_hs__and2_1_0.B sky130_fd_sc_hs__and2_1_2.B 0
C200 sky130_fd_sc_hs__and2_1_2.B sky130_fd_sc_hs__and2_1_1.X 0.35019f
C201 sky130_fd_sc_hs__xor2_1_4.B sky130_fd_sc_hs__and2_1_2.X 0
C202 sky130_fd_sc_hs__dfxtp_1_0.D sky130_fd_sc_hs__xor2_1_6.X 0
C203 sky130_fd_sc_hs__dfxtp_1_6.D VPWR 0.35654f
C204 sky130_fd_sc_hs__xor2_1_3.X sky130_fd_sc_hs__nor2b_1_3.Y 0.00123f
C205 sky130_fd_sc_hs__and2_1_0.B sky130_fd_sc_hs__xor2_1_0.X 0.32924f
C206 sky130_fd_sc_hs__xor2_1_3.X sky130_fd_sc_hs__dfxtp_1_2.D 0.02851f
C207 sky130_fd_sc_hs__nor2b_1_4.Y VPWR 0.22229f
C208 sky130_fd_sc_hs__xor2_1_4.B sky130_fd_sc_hs__and2_1_3.B 0.63058f
C209 rst sky130_fd_sc_hs__nor2b_1_7.B_N 0.13192f
C210 sky130_fd_sc_hs__xor2_1_4.B sky130_fd_sc_hs__dfxtp_1_5.D 0
C211 rst sky130_fd_sc_hs__and2_1_7.X 0.85404f
C212 overflow VPWR 0.24046f
C213 sky130_fd_sc_hs__xor2_1_1.B sky130_fd_sc_hs__and2_1_0.X 0.34915f
C214 clk sky130_fd_sc_hs__dfxtp_1_8.D 0.13487f
C215 sky130_fd_sc_hs__xor2_1_4.X sky130_fd_sc_hs__and2_1_3.X 0.05163f
C216 sky130_fd_sc_hs__and2_1_2.B VPWR 2.16206f
C217 sky130_fd_sc_hs__xor2_1_3.X sky130_fd_sc_hs__and2_1_2.X 0.05784f
C218 sky130_fd_sc_hs__dfxtp_1_0.D sky130_fd_sc_hs__and2_1_7.B 0.00149f
C219 sky130_fd_sc_hs__and2_1_6.X sky130_fd_sc_hs__xor2_1_5.X 0
C220 rst sky130_fd_sc_hs__and2_1_4.X 0
C221 sky130_fd_sc_hs__xor2_1_0.X VPWR 0.37776f
C222 sky130_fd_sc_hs__xor2_1_1.B sky130_fd_sc_hs__xor2_1_3.X 0
C223 sky130_fd_sc_hs__and2_1_3.B sky130_fd_sc_hs__xor2_1_3.X 0.35663f
C224 sky130_fd_sc_hs__xor2_1_4.B sky130_fd_sc_hs__nor2b_1_7.B_N 0
C225 en rst 0.00117f
C226 sky130_fd_sc_hs__xor2_1_5.X sky130_fd_sc_hs__nor2b_1_3.Y 0.00597f
C227 sky130_fd_sc_hs__xor2_1_4.B sky130_fd_sc_hs__and2_1_7.X 0.0957f
C228 rst sky130_fd_sc_hs__xor2_1_2.X 0.08262f
C229 sky130_fd_sc_hs__dfxtp_1_0.D VPWR 0.40339f
C230 sky130_fd_sc_hs__xor2_1_1.X sky130_fd_sc_hs__and2_1_2.B 0.00177f
C231 sky130_fd_sc_hs__and2_1_0.B sky130_fd_sc_hs__dfxtp_1_8.D 0.02596f
C232 sky130_fd_sc_hs__nor2b_1_3.Y sky130_fd_sc_hs__dfxtp_1_2.D 0.00132f
C233 sky130_fd_sc_hs__xor2_1_4.B sky130_fd_sc_hs__and2_1_4.X 0.06669f
C234 rst sky130_fd_sc_hs__nor2b_1_7.Y 0.02923f
C235 sky130_fd_sc_hs__xor2_1_1.X sky130_fd_sc_hs__xor2_1_0.X 0.00229f
C236 sky130_fd_sc_hs__xor2_1_2.X sky130_fd_sc_hs__xor2_1_4.B 0
C237 sky130_fd_sc_hs__xor2_1_5.X sky130_fd_sc_hs__and2_1_3.B 0.21417f
C238 sky130_fd_sc_hs__and2_1_2.X sky130_fd_sc_hs__dfxtp_1_2.D 0
C239 en sky130_fd_sc_hs__and2_1_0.X 0.01409f
C240 sky130_fd_sc_hs__and2_1_6.X sky130_fd_sc_hs__and2_1_3.B 0.00773f
C241 sky130_fd_sc_hs__xor2_1_5.X sky130_fd_sc_hs__dfxtp_1_5.D 0.00232f
C242 sky130_fd_sc_hs__xor2_1_2.X sky130_fd_sc_hs__and2_1_0.X 0
C243 sky130_fd_sc_hs__and2_1_2.B sky130_fd_sc_hs__and2_1_3.X 0
C244 sky130_fd_sc_hs__xor2_1_4.X sky130_fd_sc_hs__and2_1_5.X 0
C245 sky130_fd_sc_hs__dfxtp_1_8.D VPWR 0.36706f
C246 sky130_fd_sc_hs__xor2_1_3.X sky130_fd_sc_hs__and2_1_4.X 0.00382f
C247 sky130_fd_sc_hs__xor2_1_1.B sky130_fd_sc_hs__dfxtp_1_2.D 0.00138f
C248 sky130_fd_sc_hs__and2_1_3.B sky130_fd_sc_hs__nor2b_1_3.Y 0.003f
C249 sky130_fd_sc_hs__and2_1_3.B sky130_fd_sc_hs__dfxtp_1_2.D 0
C250 sky130_fd_sc_hs__xor2_1_2.X sky130_fd_sc_hs__xor2_1_3.X 0.05869f
C251 sky130_fd_sc_hs__xor2_1_5.X sky130_fd_sc_hs__nor2b_1_7.B_N 0
C252 sky130_fd_sc_hs__xor2_1_1.B sky130_fd_sc_hs__and2_1_2.X 0
C253 sky130_fd_sc_hs__and2_1_3.B sky130_fd_sc_hs__and2_1_2.X 0.34925f
C254 sky130_fd_sc_hs__and2_1_6.X sky130_fd_sc_hs__nor2b_1_7.B_N 0.04663f
C255 sky130_fd_sc_hs__xor2_1_5.X sky130_fd_sc_hs__and2_1_7.X 0.24773f
C256 sky130_fd_sc_hs__dfxtp_1_1.D sky130_fd_sc_hs__and2_1_2.B 0.00357f
C257 sky130_fd_sc_hs__and2_1_6.X sky130_fd_sc_hs__and2_1_7.X 0.00689f
C258 sky130_fd_sc_hs__xor2_1_1.B sky130_fd_sc_hs__and2_1_3.B 0
C259 clk sky130_fd_sc_hs__xor2_1_5.B 0.33548f
C260 sky130_fd_sc_hs__xor2_1_1.X sky130_fd_sc_hs__dfxtp_1_8.D 0
C261 sky130_fd_sc_hs__xor2_1_5.X sky130_fd_sc_hs__and2_1_4.X 0.11728f
C262 sky130_fd_sc_hs__xor2_1_5.B sky130_fd_sc_hs__and2_1_6.B 0.45405f
C263 rst sky130_fd_sc_hs__xor2_1_4.X 0.11783f
C264 sky130_fd_sc_hs__nor2b_1_3.Y sky130_fd_sc_hs__and2_1_4.X 0
C265 sky130_fd_sc_hs__xor2_1_5.B sky130_fd_sc_hs__xor2_1_6.X 0.23512f
C266 sky130_fd_sc_hs__and2_1_3.B sky130_fd_sc_hs__nor2b_1_7.B_N 0.00338f
C267 sky130_fd_sc_hs__xor2_1_2.X sky130_fd_sc_hs__dfxtp_1_2.D 0.00524f
C268 sky130_fd_sc_hs__and2_1_3.B sky130_fd_sc_hs__and2_1_7.X 0.02139f
C269 sky130_fd_sc_hs__xor2_1_5.X sky130_fd_sc_hs__nor2b_1_7.Y 0
C270 sky130_fd_sc_hs__dfxtp_1_5.D sky130_fd_sc_hs__and2_1_7.X 0.30365f
C271 sky130_fd_sc_hs__and2_1_6.X sky130_fd_sc_hs__nor2b_1_7.Y 0
C272 sky130_fd_sc_hs__xor2_1_5.B sky130_fd_sc_hs__and2_1_7.B 0.50106f
C273 sky130_fd_sc_hs__xor2_1_2.X sky130_fd_sc_hs__and2_1_2.X 0.1178f
C274 sky130_fd_sc_hs__xor2_1_4.B sky130_fd_sc_hs__xor2_1_4.X 0.44473f
C275 sky130_fd_sc_hs__and2_1_3.B sky130_fd_sc_hs__and2_1_4.X 0.15321f
C276 sky130_fd_sc_hs__dfxtp_1_1.D sky130_fd_sc_hs__dfxtp_1_8.D 0.00153f
C277 clk sky130_fd_sc_hs__and2_1_6.B 0.58375f
C278 en sky130_fd_sc_hs__xor2_1_1.B 0
C279 rst sky130_fd_sc_hs__dfxtp_1_6.D 0.0297f
C280 sky130_fd_sc_hs__xor2_1_1.B sky130_fd_sc_hs__xor2_1_2.X 0.06002f
C281 sky130_fd_sc_hs__xor2_1_2.X sky130_fd_sc_hs__and2_1_3.B 0.0206f
C282 sky130_fd_sc_hs__and2_1_7.X sky130_fd_sc_hs__nor2b_1_7.B_N 0.24196f
C283 clk sky130_fd_sc_hs__xor2_1_6.X 0.25364f
C284 sky130_fd_sc_hs__xor2_1_5.B VPWR 1.71866f
C285 rst sky130_fd_sc_hs__nor2b_1_4.Y 0.03192f
C286 sky130_fd_sc_hs__xor2_1_4.X sky130_fd_sc_hs__xor2_1_3.X 0.29056f
C287 sky130_fd_sc_hs__xor2_1_6.X sky130_fd_sc_hs__and2_1_6.B 0.49594f
C288 rst sky130_fd_sc_hs__and2_1_2.B 0.08702f
C289 sky130_fd_sc_hs__and2_1_0.B clk 0.00329f
C290 clk sky130_fd_sc_hs__and2_1_1.X 0.00382f
C291 clk sky130_fd_sc_hs__and2_1_7.B 0.08942f
C292 sky130_fd_sc_hs__dfxtp_1_5.D sky130_fd_sc_hs__nor2b_1_7.Y 0
C293 rst sky130_fd_sc_hs__xor2_1_0.X 0.12302f
C294 sky130_fd_sc_hs__xor2_1_4.B sky130_fd_sc_hs__nor2b_1_4.Y 0.22863f
C295 sky130_fd_sc_hs__and2_1_7.B sky130_fd_sc_hs__and2_1_6.B 0.54124f
C296 sky130_fd_sc_hs__xor2_1_6.X sky130_fd_sc_hs__and2_1_7.B 0.00793f
C297 sky130_fd_sc_hs__xor2_1_4.B sky130_fd_sc_hs__and2_1_2.B 0.0108f
C298 rst sky130_fd_sc_hs__dfxtp_1_0.D 0.03394f
C299 sky130_fd_sc_hs__xor2_1_5.X sky130_fd_sc_hs__xor2_1_4.X 0.53792f
C300 clk VPWR 1.7195f
C301 sky130_fd_sc_hs__nor2b_1_7.Y sky130_fd_sc_hs__nor2b_1_7.B_N 0.01039f
C302 sky130_fd_sc_hs__and2_1_2.B sky130_fd_sc_hs__and2_1_0.X 0
C303 sky130_fd_sc_hs__and2_1_7.X sky130_fd_sc_hs__nor2b_1_7.Y 0
C304 VPWR sky130_fd_sc_hs__and2_1_6.B 1.03451f
C305 sky130_fd_sc_hs__xor2_1_4.X sky130_fd_sc_hs__nor2b_1_3.Y 0.16679f
C306 sky130_fd_sc_hs__xor2_1_4.X sky130_fd_sc_hs__dfxtp_1_2.D 0
C307 sky130_fd_sc_hs__and2_1_0.B sky130_fd_sc_hs__and2_1_1.X 0
C308 sky130_fd_sc_hs__xor2_1_5.B sky130_fd_sc_hs__and2_1_3.X 0
C309 sky130_fd_sc_hs__xor2_1_0.X sky130_fd_sc_hs__and2_1_0.X 0.00149f
C310 sky130_fd_sc_hs__xor2_1_6.X VPWR 2.06347f
C311 sky130_fd_sc_hs__xor2_1_3.X sky130_fd_sc_hs__and2_1_2.B 0.25358f
C312 sky130_fd_sc_hs__xor2_1_4.X sky130_fd_sc_hs__and2_1_2.X 0
C313 rst sky130_fd_sc_hs__dfxtp_1_8.D 0.0312f
C314 sky130_fd_sc_hs__xor2_1_1.X clk 0
C315 overflow 0 0.39167f
C316 en 0 1.70113f
C317 clk 0 5.70538f
C318 rst 0 3.45202f
C319 VPWR 0 52.15828f
C320 sky130_fd_sc_hs__dfxtp_1_0.D 0 0.75643f
C321 sky130_fd_sc_hs__nor2b_1_7.Y 0 0.79558f
C322 sky130_fd_sc_hs__and2_1_7.X 0 0.9039f
C323 sky130_fd_sc_hs__nor2b_1_7.B_N 0 0.41401f
C324 sky130_fd_sc_hs__and2_1_7.B 0 2.32465f
C325 sky130_fd_sc_hs__and2_1_6.X 0 1.85814f
C326 sky130_fd_sc_hs__and2_1_5.X 0 1.90404f
C327 sky130_fd_sc_hs__and2_1_4.X 0 1.76809f
C328 sky130_fd_sc_hs__and2_1_3.X 0 1.78456f
C329 sky130_fd_sc_hs__and2_1_2.X 0 1.75648f
C330 sky130_fd_sc_hs__and2_1_1.X 0 1.74437f
C331 sky130_fd_sc_hs__and2_1_0.X 0 1.84068f
C332 sky130_fd_sc_hs__and2_1_6.B 0 2.0914f
C333 sky130_fd_sc_hs__dfxtp_1_6.D 0 0.68958f
C334 sky130_fd_sc_hs__xor2_1_6.X 0 0.89498f
C335 sky130_fd_sc_hs__xor2_1_5.B 0 1.71195f
C336 sky130_fd_sc_hs__dfxtp_1_5.D 0 0.76545f
C337 sky130_fd_sc_hs__xor2_1_5.X 0 2.19234f
C338 sky130_fd_sc_hs__xor2_1_4.B 0 1.05895f
C339 sky130_fd_sc_hs__nor2b_1_4.Y 0 0.70408f
C340 sky130_fd_sc_hs__xor2_1_4.X 0 1.51009f
C341 sky130_fd_sc_hs__and2_1_3.B 0 1.05014f
C342 sky130_fd_sc_hs__nor2b_1_3.Y 0 0.72259f
C343 sky130_fd_sc_hs__xor2_1_3.X 0 0.69886f
C344 sky130_fd_sc_hs__and2_1_2.B 0 1.01976f
C345 sky130_fd_sc_hs__dfxtp_1_2.D 0 0.74127f
C346 sky130_fd_sc_hs__xor2_1_2.X 0 0.57211f
C347 sky130_fd_sc_hs__xor2_1_1.B 0 1.92721f
C348 sky130_fd_sc_hs__dfxtp_1_1.D 0 0.66937f
C349 sky130_fd_sc_hs__xor2_1_1.X 0 0.54092f
C350 sky130_fd_sc_hs__and2_1_0.B 0 1.57536f
C351 sky130_fd_sc_hs__dfxtp_1_8.D 0 0.68372f
C352 sky130_fd_sc_hs__xor2_1_0.X 0 1.09166f
C353 a_1423_n397.t1 0 0.12127f
C354 a_1423_n397.t0 0 0.09187f
C355 a_1423_n397.t3 0 0.05137f
C356 a_1423_n397.t2 0 0.03518f
C357 a_1423_n397.n0 0 0.11136f
C358 a_1423_n397.n1 0 0.35006f
C359 a_1903_n435.t1 0 0.1177f
C360 a_1903_n435.t7 0 0.07511f
C361 a_1903_n435.t5 0 0.0447f
C362 a_1903_n435.n0 0 0.12238f
C363 a_1903_n435.n1 0 0.31101f
C364 a_1903_n435.t0 0 0.22562f
C365 a_1903_n435.t6 0 0.03917f
C366 a_1903_n435.t3 0 0.04882f
C367 a_1903_n435.n2 0 0.1817f
C368 a_1903_n435.n3 0 0.60877f
C369 a_1903_n435.t2 0 0.22991f
C370 a_1903_n435.t4 0 0.1338f
C371 a_1903_n435.n4 0 0.41619f
C372 sky130_fd_sc_hs__xor2_1_0.X.t1 0 0.03643f
C373 sky130_fd_sc_hs__xor2_1_0.X.n0 0 0.05464f
C374 sky130_fd_sc_hs__xor2_1_0.X.n1 0 0.02895f
C375 sky130_fd_sc_hs__xor2_1_0.X.n2 0 0.55481f
C376 sky130_fd_sc_hs__xor2_1_0.X.t0 0 0.12089f
C377 sky130_fd_sc_hs__xor2_1_0.X.t4 0 0.03388f
C378 sky130_fd_sc_hs__xor2_1_0.X.n3 0 0.09538f
C379 sky130_fd_sc_hs__xor2_1_0.X.t3 0 0.01839f
C380 sky130_fd_sc_hs__xor2_1_0.X.n4 0 0.49001f
C381 sky130_fd_sc_hs__xor2_1_0.X.n5 0 0.09245f
C382 sky130_fd_sc_hs__xor2_1_0.X.t2 0 0.01821f
C383 a_1674_n141.t0 0 0.02085f
C384 a_1674_n141.t1 0 0.02085f
C385 sky130_fd_sc_hs__dfxtp_1_8.D.t0 0 0.02497f
C386 sky130_fd_sc_hs__dfxtp_1_8.D.n0 0 0.13666f
C387 sky130_fd_sc_hs__dfxtp_1_8.D.n1 0 0.02333f
C388 sky130_fd_sc_hs__dfxtp_1_8.D.n2 0 0.16093f
C389 sky130_fd_sc_hs__dfxtp_1_8.D.t2 0 0.04185f
C390 sky130_fd_sc_hs__dfxtp_1_8.D.n3 0 0.03924f
C391 sky130_fd_sc_hs__dfxtp_1_8.D.n4 0 0.19018f
C392 sky130_fd_sc_hs__dfxtp_1_8.D.t4 0 0.06406f
C393 sky130_fd_sc_hs__dfxtp_1_8.D.n5 0 0.23207f
C394 sky130_fd_sc_hs__dfxtp_1_8.D.t3 0 0.06965f
C395 sky130_fd_sc_hs__dfxtp_1_8.D.n6 0 0.02705f
C396 sky130_fd_sc_hs__dfxtp_1_8.D.t1 0 0.03835f
C397 a_2082_n141.t0 0 0.15447f
C398 a_2082_n141.t5 0 0.10524f
C399 a_2082_n141.t3 0 0.18091f
C400 a_2082_n141.n0 0 0.33425f
C401 a_2082_n141.n1 0 0.23444f
C402 a_2082_n141.n2 0 0.48369f
C403 a_2082_n141.t2 0 0.14209f
C404 a_2082_n141.t4 0 0.14121f
C405 a_2082_n141.n3 0 0.72868f
C406 a_2082_n141.t1 0 0.18745f
C407 a_2589_n51.t0 0 0.00408f
C408 a_2589_n51.t5 0 0.07222f
C409 a_2589_n51.t4 0 0.02583f
C410 a_2589_n51.n0 0 0.15293f
C411 a_2589_n51.t2 0 0.0358f
C412 a_2589_n51.t1 0 0.08839f
C413 a_2589_n51.n1 0 0.13409f
C414 a_2589_n51.n2 0 0.27553f
C415 a_2589_n51.t3 0 0.03095f
C416 a_2589_n51.n3 0 0.0914f
C417 a_2437_n46.t0 0 0.01972f
C418 a_2437_n46.t2 0 0.04386f
C419 a_2437_n46.t4 0 0.07707f
C420 a_2437_n46.t5 0 0.06119f
C421 a_2437_n46.n0 0 0.23196f
C422 a_2437_n46.t3 0 0.02224f
C423 a_2437_n46.t1 0 0.02922f
C424 a_2437_n46.n1 0 0.12329f
C425 a_2437_n46.n2 0 0.44786f
C426 a_2437_n46.n3 0 0.06364f
C427 a_3086_n195.t1 0 0.09969f
C428 a_3086_n195.t4 0 0.05477f
C429 a_3086_n195.t2 0 0.03907f
C430 a_3086_n195.n0 0 0.0853f
C431 a_3086_n195.n1 0 0.19603f
C432 a_3086_n195.n2 0 0.15494f
C433 a_3086_n195.t5 0 0.03352f
C434 a_3086_n195.t3 0 0.0378f
C435 a_3086_n195.n3 0 0.23729f
C436 a_3086_n195.t0 0 0.09533f
C437 a_3535_n397.t1 0 0.12843f
C438 a_3535_n397.t0 0 0.0973f
C439 a_3535_n397.t3 0 0.0544f
C440 a_3535_n397.t2 0 0.03726f
C441 a_3535_n397.n0 0 0.11794f
C442 a_3535_n397.n1 0 0.37072f
C443 a_4015_n435.t1 0 0.11667f
C444 a_4015_n435.t7 0 0.07445f
C445 a_4015_n435.t5 0 0.04431f
C446 a_4015_n435.n0 0 0.12131f
C447 a_4015_n435.n1 0 0.30828f
C448 a_4015_n435.t0 0 0.22364f
C449 a_4015_n435.t6 0 0.03882f
C450 a_4015_n435.t3 0 0.0484f
C451 a_4015_n435.n2 0 0.18011f
C452 a_4015_n435.n3 0 0.60342f
C453 a_4015_n435.t2 0 0.22789f
C454 a_4015_n435.t4 0 0.13262f
C455 a_4015_n435.n4 0 0.41254f
C456 a_2330_n6.n0 0 0.01931f
C457 a_2330_n6.t0 0 0.0063f
C458 a_2330_n6.t1 0 0.0153f
C459 a_2330_n6.n1 0 0.08437f
C460 a_2330_n6.t2 0 0.02601f
C461 a_2330_n6.t3 0 0.02723f
C462 a_2330_n6.n2 0 0.20877f
C463 a_2330_n6.n3 0 0.01964f
C464 a_2544_n6.t0 0 0.00472f
C465 a_2544_n6.t1 0 0.00472f
C466 a_2887_n85.t2 0 0.02533f
C467 a_2887_n85.t1 0 0.03061f
C468 a_2887_n85.t0 0 0.03364f
C469 a_2887_n85.t3 0 0.02586f
C470 a_2887_n85.n0 0 0.0698f
C471 a_2887_n85.n1 0 0.35377f
C472 a_2887_n85.t5 0 0.05339f
C473 a_2887_n85.t4 0 0.03726f
C474 a_2887_n85.n2 0 0.14105f
C475 a_2887_n85.n3 0 0.1014f
C476 a_2994_n1.t0 0 0.00892f
C477 a_2994_n1.t1 0 0.00892f
C478 sky130_fd_sc_hs__and2_1_0.B.t1 0 0.07295f
C479 sky130_fd_sc_hs__and2_1_0.B.n0 0 0.02143f
C480 sky130_fd_sc_hs__and2_1_0.B.n1 0 0.42582f
C481 sky130_fd_sc_hs__and2_1_0.B.t7 0 0.05694f
C482 sky130_fd_sc_hs__and2_1_0.B.t4 0 0.03417f
C483 sky130_fd_sc_hs__and2_1_0.B.n2 0 0.13949f
C484 sky130_fd_sc_hs__and2_1_0.B.t6 0 0.05694f
C485 sky130_fd_sc_hs__and2_1_0.B.t3 0 0.03853f
C486 sky130_fd_sc_hs__and2_1_0.B.n3 0 0.08636f
C487 sky130_fd_sc_hs__and2_1_0.B.n4 0 0.03228f
C488 sky130_fd_sc_hs__and2_1_0.B.n5 0 0.01696f
C489 sky130_fd_sc_hs__and2_1_0.B.t5 0 0.05257f
C490 sky130_fd_sc_hs__and2_1_0.B.t2 0 0.0315f
C491 sky130_fd_sc_hs__and2_1_0.B.n6 0 0.09047f
C492 sky130_fd_sc_hs__and2_1_0.B.n7 0 0.05331f
C493 sky130_fd_sc_hs__and2_1_0.B.n8 0 0.87801f
C494 sky130_fd_sc_hs__and2_1_0.B.t0 0 0.19187f
C495 sky130_fd_sc_hs__and2_1_0.B.n9 0 0.23008f
C496 sky130_fd_sc_hs__xor2_1_1.X.t0 0 0.02182f
C497 sky130_fd_sc_hs__xor2_1_1.X.n0 0 0.06546f
C498 sky130_fd_sc_hs__xor2_1_1.X.n1 0 0.03468f
C499 sky130_fd_sc_hs__xor2_1_1.X.n2 0 0.42769f
C500 sky130_fd_sc_hs__xor2_1_1.X.t1 0 0.14493f
C501 sky130_fd_sc_hs__xor2_1_1.X.t4 0 0.04059f
C502 sky130_fd_sc_hs__xor2_1_1.X.n3 0 0.11426f
C503 sky130_fd_sc_hs__xor2_1_1.X.t3 0 0.02203f
C504 sky130_fd_sc_hs__xor2_1_1.X.n4 0 0.40383f
C505 sky130_fd_sc_hs__xor2_1_1.X.n5 0 0.11069f
C506 sky130_fd_sc_hs__xor2_1_1.X.t2 0 0.04364f
C507 a_3786_n141.t0 0 0.02098f
C508 a_3786_n141.t1 0 0.02098f
C509 sky130_fd_sc_hs__dfxtp_1_1.D.t0 0 0.02497f
C510 sky130_fd_sc_hs__dfxtp_1_1.D.n0 0 0.13667f
C511 sky130_fd_sc_hs__dfxtp_1_1.D.n1 0 0.02705f
C512 sky130_fd_sc_hs__dfxtp_1_1.D.n2 0 0.16094f
C513 sky130_fd_sc_hs__dfxtp_1_1.D.t1 0 0.04185f
C514 sky130_fd_sc_hs__dfxtp_1_1.D.n3 0 0.03925f
C515 sky130_fd_sc_hs__dfxtp_1_1.D.n4 0 0.19792f
C516 sky130_fd_sc_hs__dfxtp_1_1.D.t4 0 0.0641f
C517 sky130_fd_sc_hs__dfxtp_1_1.D.t3 0 0.06965f
C518 sky130_fd_sc_hs__dfxtp_1_1.D.n5 0 0.02659f
C519 sky130_fd_sc_hs__dfxtp_1_1.D.n6 0 0.2445f
C520 sky130_fd_sc_hs__dfxtp_1_1.D.t2 0 0.03835f
C521 a_4194_n141.t1 0 0.15817f
C522 a_4194_n141.t5 0 0.10776f
C523 a_4194_n141.t3 0 0.18524f
C524 a_4194_n141.n0 0 0.34225f
C525 a_4194_n141.n1 0 0.24005f
C526 a_4194_n141.n2 0 0.49527f
C527 a_4194_n141.t2 0 0.14549f
C528 a_4194_n141.t4 0 0.14459f
C529 a_4194_n141.n3 0 0.74612f
C530 a_4194_n141.t0 0 0.19193f
C531 a_4701_n51.t1 0 0.03132f
C532 a_4701_n51.t5 0 0.07309f
C533 a_4701_n51.t4 0 0.02614f
C534 a_4701_n51.n0 0 0.15477f
C535 a_4701_n51.t0 0 0.03623f
C536 a_4701_n51.t2 0 0.08945f
C537 a_4701_n51.n1 0 0.13571f
C538 a_4701_n51.n2 0 0.27885f
C539 a_4701_n51.t3 0 0.00412f
C540 a_4701_n51.n3 0 0.0925f
C541 a_4549_n46.n0 0 0.01447f
C542 a_4549_n46.t0 0 0.00482f
C543 a_4549_n46.n1 0 0.09921f
C544 a_4549_n46.t3 0 0.01959f
C545 a_4549_n46.t1 0 0.04357f
C546 a_4549_n46.n2 0 0.06322f
C547 a_4549_n46.n3 0 0.44488f
C548 a_4549_n46.t4 0 0.07656f
C549 a_4549_n46.t5 0 0.06079f
C550 a_4549_n46.n4 0 0.23042f
C551 a_4549_n46.t2 0 0.02902f
C552 a_4549_n46.n5 0 0.02605f
C553 a_5198_n195.t1 0 0.10294f
C554 a_5198_n195.t4 0 0.05656f
C555 a_5198_n195.t2 0 0.04035f
C556 a_5198_n195.n0 0 0.08808f
C557 a_5198_n195.n1 0 0.20242f
C558 a_5198_n195.n2 0 0.15999f
C559 a_5198_n195.t5 0 0.03461f
C560 a_5198_n195.t3 0 0.03903f
C561 a_5198_n195.n3 0 0.24503f
C562 a_5198_n195.t0 0 0.09844f
C563 a_5647_n397.t1 0 0.12733f
C564 a_5647_n397.t0 0 0.09646f
C565 a_5647_n397.t3 0 0.05393f
C566 a_5647_n397.t2 0 0.03694f
C567 a_5647_n397.n0 0 0.11693f
C568 a_5647_n397.n1 0 0.36754f
C569 a_6127_n435.t1 0 0.11212f
C570 a_6127_n435.t7 0 0.07155f
C571 a_6127_n435.t5 0 0.04258f
C572 a_6127_n435.n0 0 0.11658f
C573 a_6127_n435.n1 0 0.29626f
C574 a_6127_n435.t0 0 0.21492f
C575 a_6127_n435.t6 0 0.03731f
C576 a_6127_n435.t3 0 0.04651f
C577 a_6127_n435.n2 0 0.17309f
C578 a_6127_n435.n3 0 0.5799f
C579 a_6127_n435.t2 0 0.21901f
C580 a_6127_n435.t4 0 0.12745f
C581 a_6127_n435.n4 0 0.39645f
C582 a_4442_n6.t0 0 0.02599f
C583 a_4442_n6.t1 0 0.03264f
C584 a_4442_n6.n0 0 0.09687f
C585 a_4442_n6.t3 0 0.01529f
C586 a_4442_n6.n1 0 0.2086f
C587 a_4442_n6.t2 0 0.0272f
C588 a_4656_n6.t0 0 0.0049f
C589 a_4656_n6.t1 0 0.0049f
C590 a_2607_n408.t0 0 0.00343f
C591 a_2607_n408.t1 0 0.00343f
C592 a_3044_n385.t0 0 0.00539f
C593 a_3044_n385.t1 0 0.00539f
C594 a_4999_n85.t1 0 0.02625f
C595 a_4999_n85.t0 0 0.03171f
C596 a_4999_n85.t3 0 0.03485f
C597 a_4999_n85.t2 0 0.02679f
C598 a_4999_n85.n0 0 0.07231f
C599 a_4999_n85.n1 0 0.36651f
C600 a_4999_n85.t5 0 0.05532f
C601 a_4999_n85.t4 0 0.0386f
C602 a_4999_n85.n2 0 0.14613f
C603 a_4999_n85.n3 0 0.10505f
C604 a_5106_n1.t0 0 0.01004f
C605 a_5106_n1.t1 0 0.01004f
C606 sky130_fd_sc_hs__xor2_1_1.B.t1 0 0.06951f
C607 sky130_fd_sc_hs__xor2_1_1.B.n0 0 0.03052f
C608 sky130_fd_sc_hs__xor2_1_1.B.n1 0 0.64978f
C609 sky130_fd_sc_hs__xor2_1_1.B.n2 0 1.11333f
C610 sky130_fd_sc_hs__xor2_1_1.B.t5 0 0.05009f
C611 sky130_fd_sc_hs__xor2_1_1.B.t2 0 0.03002f
C612 sky130_fd_sc_hs__xor2_1_1.B.n3 0 0.08612f
C613 sky130_fd_sc_hs__xor2_1_1.B.n4 0 0.04428f
C614 sky130_fd_sc_hs__xor2_1_1.B.t7 0 0.05426f
C615 sky130_fd_sc_hs__xor2_1_1.B.t4 0 0.03256f
C616 sky130_fd_sc_hs__xor2_1_1.B.n5 0 0.13293f
C617 sky130_fd_sc_hs__xor2_1_1.B.t6 0 0.05426f
C618 sky130_fd_sc_hs__xor2_1_1.B.t3 0 0.03671f
C619 sky130_fd_sc_hs__xor2_1_1.B.n6 0 0.0823f
C620 sky130_fd_sc_hs__xor2_1_1.B.n7 0 0.0304f
C621 sky130_fd_sc_hs__xor2_1_1.B.n8 0 0.02713f
C622 sky130_fd_sc_hs__xor2_1_1.B.t0 0 0.18284f
C623 sky130_fd_sc_hs__xor2_1_1.B.n9 0 0.21925f
C624 sky130_fd_sc_hs__xor2_1_2.X.t0 0 0.02759f
C625 sky130_fd_sc_hs__xor2_1_2.X.n0 0 0.08276f
C626 sky130_fd_sc_hs__xor2_1_2.X.n1 0 0.04384f
C627 sky130_fd_sc_hs__xor2_1_2.X.n2 0 0.77545f
C628 sky130_fd_sc_hs__xor2_1_2.X.t1 0 0.18305f
C629 sky130_fd_sc_hs__xor2_1_2.X.t4 0 0.05132f
C630 sky130_fd_sc_hs__xor2_1_2.X.n3 0 0.14437f
C631 sky130_fd_sc_hs__xor2_1_2.X.t3 0 0.02785f
C632 sky130_fd_sc_hs__xor2_1_2.X.n4 0 0.76231f
C633 sky130_fd_sc_hs__xor2_1_2.X.n5 0 0.14096f
C634 sky130_fd_sc_hs__xor2_1_2.X.t2 0 0.05517f
C635 a_5898_n141.t0 0 0.02031f
C636 a_5898_n141.t1 0 0.02031f
C637 sky130_fd_sc_hs__dfxtp_1_2.D.t0 0 0.02551f
C638 sky130_fd_sc_hs__dfxtp_1_2.D.n0 0 0.13961f
C639 sky130_fd_sc_hs__dfxtp_1_2.D.n1 0 0.02925f
C640 sky130_fd_sc_hs__dfxtp_1_2.D.n2 0 0.16441f
C641 sky130_fd_sc_hs__dfxtp_1_2.D.t1 0 0.04275f
C642 sky130_fd_sc_hs__dfxtp_1_2.D.n3 0 0.04009f
C643 sky130_fd_sc_hs__dfxtp_1_2.D.n4 0 0.1713f
C644 sky130_fd_sc_hs__dfxtp_1_2.D.t4 0 0.06544f
C645 sky130_fd_sc_hs__dfxtp_1_2.D.n5 0 0.21569f
C646 sky130_fd_sc_hs__dfxtp_1_2.D.t3 0 0.07115f
C647 sky130_fd_sc_hs__dfxtp_1_2.D.n6 0 0.02763f
C648 sky130_fd_sc_hs__dfxtp_1_2.D.t2 0 0.03918f
C649 a_6306_n141.t0 0 0.16093f
C650 a_6306_n141.t5 0 0.10964f
C651 a_6306_n141.t3 0 0.18847f
C652 a_6306_n141.n0 0 0.34822f
C653 a_6306_n141.n1 0 0.24424f
C654 a_6306_n141.n2 0 0.5039f
C655 a_6306_n141.t2 0 0.14803f
C656 a_6306_n141.t4 0 0.14711f
C657 a_6306_n141.n3 0 0.75913f
C658 a_6306_n141.t1 0 0.19528f
C659 a_6813_n51.t0 0 0.00428f
C660 a_6813_n51.t5 0 0.07576f
C661 a_6813_n51.t4 0 0.0271f
C662 a_6813_n51.n0 0 0.16041f
C663 a_6813_n51.t2 0 0.03755f
C664 a_6813_n51.t1 0 0.09271f
C665 a_6813_n51.n1 0 0.14066f
C666 a_6813_n51.n2 0 0.28902f
C667 a_6813_n51.t3 0 0.03246f
C668 a_6813_n51.n3 0 0.09587f
C669 a_6661_n46.n0 0 0.01506f
C670 a_6661_n46.t0 0 0.00502f
C671 a_6661_n46.n1 0 0.10689f
C672 a_6661_n46.t1 0 0.02038f
C673 a_6661_n46.t3 0 0.04532f
C674 a_6661_n46.n2 0 0.06576f
C675 a_6661_n46.n3 0 0.46278f
C676 a_6661_n46.t4 0 0.07964f
C677 a_6661_n46.t5 0 0.06323f
C678 a_6661_n46.n4 0 0.23969f
C679 a_6661_n46.t2 0 0.02298f
C680 a_6661_n46.n5 0 0.03061f
C681 a_7310_n195.t1 0 0.10779f
C682 a_7310_n195.t4 0 0.05923f
C683 a_7310_n195.t2 0 0.04225f
C684 a_7310_n195.n0 0 0.09223f
C685 a_7310_n195.n1 0 0.21196f
C686 a_7310_n195.n2 0 0.16754f
C687 a_7310_n195.t5 0 0.03624f
C688 a_7310_n195.t3 0 0.04087f
C689 a_7310_n195.n3 0 0.25658f
C690 a_7310_n195.t0 0 0.10308f
C691 a_7759_n397.t1 0 0.13321f
C692 a_7759_n397.t0 0 0.10092f
C693 a_7759_n397.t3 0 0.05643f
C694 a_7759_n397.t2 0 0.03864f
C695 a_7759_n397.n0 0 0.12233f
C696 a_7759_n397.n1 0 0.38453f
C697 a_8239_n435.t1 0 0.11985f
C698 a_8239_n435.t7 0 0.07649f
C699 a_8239_n435.t5 0 0.04552f
C700 a_8239_n435.n0 0 0.12462f
C701 a_8239_n435.n1 0 0.3167f
C702 a_8239_n435.t0 0 0.22975f
C703 a_8239_n435.t6 0 0.03988f
C704 a_8239_n435.t3 0 0.04972f
C705 a_8239_n435.n2 0 0.18503f
C706 a_8239_n435.n3 0 0.6199f
C707 a_8239_n435.t2 0 0.23412f
C708 a_8239_n435.t4 0 0.13624f
C709 a_8239_n435.n4 0 0.4238f
C710 a_6554_n6.n0 0 0.02072f
C711 a_6554_n6.t0 0 0.00676f
C712 a_6554_n6.t2 0 0.01642f
C713 a_6554_n6.n1 0 0.09055f
C714 a_6554_n6.t3 0 0.02792f
C715 a_6554_n6.t1 0 0.02922f
C716 a_6554_n6.n2 0 0.22407f
C717 a_6554_n6.n3 0 0.02107f
C718 a_6768_n6.t0 0 0.00458f
C719 a_6768_n6.t1 0 0.00458f
C720 a_4719_n408.t0 0 0.0033f
C721 a_4719_n408.t1 0 0.0033f
C722 a_5156_n385.t0 0 0.0055f
C723 a_5156_n385.t1 0 0.0055f
C724 a_7111_n85.t2 0 0.02795f
C725 a_7111_n85.t1 0 0.03377f
C726 a_7111_n85.t0 0 0.03711f
C727 a_7111_n85.t3 0 0.02853f
C728 a_7111_n85.n0 0 0.07701f
C729 a_7111_n85.n1 0 0.39031f
C730 a_7111_n85.t5 0 0.05891f
C731 a_7111_n85.t4 0 0.04111f
C732 a_7111_n85.n2 0 0.15562f
C733 a_7111_n85.n3 0 0.11187f
C734 a_7218_n1.t0 0 0.00933f
C735 a_7218_n1.t1 0 0.00933f
C736 sky130_fd_sc_hs__and2_1_2.B.t0 0 0.10735f
C737 sky130_fd_sc_hs__and2_1_2.B.n0 0 0.06092f
C738 sky130_fd_sc_hs__and2_1_2.B.n1 0 1.12355f
C739 sky130_fd_sc_hs__and2_1_2.B.t5 0 0.07736f
C740 sky130_fd_sc_hs__and2_1_2.B.t2 0 0.04635f
C741 sky130_fd_sc_hs__and2_1_2.B.n2 0 0.13329f
C742 sky130_fd_sc_hs__and2_1_2.B.n3 0 0.07279f
C743 sky130_fd_sc_hs__and2_1_2.B.n4 0 2.18284f
C744 sky130_fd_sc_hs__and2_1_2.B.t7 0 0.08379f
C745 sky130_fd_sc_hs__and2_1_2.B.t4 0 0.05028f
C746 sky130_fd_sc_hs__and2_1_2.B.n5 0 0.20528f
C747 sky130_fd_sc_hs__and2_1_2.B.t6 0 0.0838f
C748 sky130_fd_sc_hs__and2_1_2.B.t3 0 0.0567f
C749 sky130_fd_sc_hs__and2_1_2.B.n6 0 0.12709f
C750 sky130_fd_sc_hs__and2_1_2.B.n7 0 0.09023f
C751 sky130_fd_sc_hs__and2_1_2.B.t1 0 0.20031f
C752 sky130_fd_sc_hs__and2_1_2.B.n8 0 0.13723f
C753 sky130_fd_sc_hs__xor2_1_3.X.t0 0 0.02797f
C754 sky130_fd_sc_hs__xor2_1_3.X.n0 0 0.0839f
C755 sky130_fd_sc_hs__xor2_1_3.X.n1 0 0.04445f
C756 sky130_fd_sc_hs__xor2_1_3.X.n2 0 0.96895f
C757 sky130_fd_sc_hs__xor2_1_3.X.t2 0 0.18546f
C758 sky130_fd_sc_hs__xor2_1_3.X.t4 0 0.05203f
C759 sky130_fd_sc_hs__xor2_1_3.X.n3 0 0.14636f
C760 sky130_fd_sc_hs__xor2_1_3.X.t3 0 0.02824f
C761 sky130_fd_sc_hs__xor2_1_3.X.n4 0 1.35455f
C762 sky130_fd_sc_hs__xor2_1_3.X.n5 0 0.14364f
C763 sky130_fd_sc_hs__xor2_1_3.X.t1 0 0.05593f
C764 a_8010_n141.t0 0 0.02123f
C765 a_8010_n141.t1 0 0.02123f
C766 sky130_fd_sc_hs__nor2b_1_3.Y.t1 0 0.02851f
C767 sky130_fd_sc_hs__nor2b_1_3.Y.n0 0 0.15602f
C768 sky130_fd_sc_hs__nor2b_1_3.Y.n1 0 0.03451f
C769 sky130_fd_sc_hs__nor2b_1_3.Y.n2 0 0.18374f
C770 sky130_fd_sc_hs__nor2b_1_3.Y.t0 0 0.04778f
C771 sky130_fd_sc_hs__nor2b_1_3.Y.n3 0 0.0448f
C772 sky130_fd_sc_hs__nor2b_1_3.Y.n4 0 0.18268f
C773 sky130_fd_sc_hs__nor2b_1_3.Y.t4 0 0.07313f
C774 sky130_fd_sc_hs__nor2b_1_3.Y.n5 0 0.22933f
C775 sky130_fd_sc_hs__nor2b_1_3.Y.t3 0 0.07952f
C776 sky130_fd_sc_hs__nor2b_1_3.Y.n6 0 0.03088f
C777 sky130_fd_sc_hs__nor2b_1_3.Y.t2 0 0.04379f
C778 a_8418_n141.t1 0 0.16482f
C779 a_8418_n141.t5 0 0.11229f
C780 a_8418_n141.t3 0 0.19302f
C781 a_8418_n141.n0 0 0.35663f
C782 a_8418_n141.n1 0 0.25014f
C783 a_8418_n141.n2 0 0.51608f
C784 a_8418_n141.t2 0 0.15161f
C785 a_8418_n141.t4 0 0.15066f
C786 a_8418_n141.n3 0 0.77747f
C787 a_8418_n141.t0 0 0.2f
C788 a_8925_n51.t1 0 0.03297f
C789 a_8925_n51.t5 0 0.07694f
C790 a_8925_n51.t4 0 0.02752f
C791 a_8925_n51.n0 0 0.16292f
C792 a_8925_n51.t0 0 0.03814f
C793 a_8925_n51.t2 0 0.09416f
C794 a_8925_n51.n1 0 0.14286f
C795 a_8925_n51.n2 0 0.29354f
C796 a_8925_n51.t3 0 0.00434f
C797 a_8925_n51.n3 0 0.09737f
C798 a_8773_n46.n0 0 0.01544f
C799 a_8773_n46.t0 0 0.00515f
C800 a_8773_n46.n1 0 0.10961f
C801 a_8773_n46.t2 0 0.02089f
C802 a_8773_n46.t1 0 0.04647f
C803 a_8773_n46.n2 0 0.06743f
C804 a_8773_n46.n3 0 0.47454f
C805 a_8773_n46.t4 0 0.08166f
C806 a_8773_n46.t5 0 0.06484f
C807 a_8773_n46.n4 0 0.24578f
C808 a_8773_n46.t3 0 0.02357f
C809 a_8773_n46.n5 0 0.03139f
C810 a_9422_n195.t1 0 0.10964f
C811 a_9422_n195.t4 0 0.06024f
C812 a_9422_n195.t2 0 0.04297f
C813 a_9422_n195.n0 0 0.09381f
C814 a_9422_n195.n1 0 0.2156f
C815 a_9422_n195.n2 0 0.17041f
C816 a_9422_n195.t5 0 0.03687f
C817 a_9422_n195.t3 0 0.04157f
C818 a_9422_n195.n3 0 0.26098f
C819 a_9422_n195.t0 0 0.10485f
C820 a_9871_n397.t1 0 0.13433f
C821 a_9871_n397.t0 0 0.10177f
C822 a_9871_n397.t3 0 0.0569f
C823 a_9871_n397.t2 0 0.03897f
C824 a_9871_n397.n0 0 0.12336f
C825 a_9871_n397.n1 0 0.38776f
C826 a_10351_n435.t1 0 0.11614f
C827 a_10351_n435.t7 0 0.07411f
C828 a_10351_n435.t5 0 0.04411f
C829 a_10351_n435.n0 0 0.12076f
C830 a_10351_n435.n1 0 0.30688f
C831 a_10351_n435.t0 0 0.22263f
C832 a_10351_n435.t6 0 0.03865f
C833 a_10351_n435.t3 0 0.04818f
C834 a_10351_n435.n2 0 0.17929f
C835 a_10351_n435.n3 0 0.60069f
C836 a_10351_n435.t2 0 0.22686f
C837 a_10351_n435.t4 0 0.13202f
C838 a_10351_n435.n4 0 0.41067f
C839 a_8666_n6.t0 0 0.03f
C840 a_8666_n6.t3 0 0.02866f
C841 a_8666_n6.t1 0 0.03599f
C842 a_8666_n6.n0 0 0.10682f
C843 a_8666_n6.t2 0 0.01686f
C844 a_8666_n6.n1 0 0.23003f
C845 a_8880_n6.t0 0 0.00457f
C846 a_8880_n6.t1 0 0.00457f
C847 a_6831_n408.t0 0 0.0036f
C848 a_6831_n408.t1 0 0.0036f
C849 a_7268_n385.t0 0 0.00622f
C850 a_7268_n385.t1 0 0.00622f
C851 a_9223_n85.t0 0 0.02791f
C852 a_9223_n85.t1 0 0.03373f
C853 a_9223_n85.t2 0 0.03706f
C854 a_9223_n85.t3 0 0.02849f
C855 a_9223_n85.n0 0 0.0769f
C856 a_9223_n85.n1 0 0.38978f
C857 a_9223_n85.t5 0 0.05883f
C858 a_9223_n85.t4 0 0.04105f
C859 a_9223_n85.n2 0 0.1554f
C860 a_9223_n85.n3 0 0.11172f
C861 a_9330_n1.t0 0 0.00907f
C862 a_9330_n1.t1 0 0.00907f
C863 sky130_fd_sc_hs__and2_1_3.B.t0 0 0.09948f
C864 sky130_fd_sc_hs__and2_1_3.B.n0 0 0.05645f
C865 sky130_fd_sc_hs__and2_1_3.B.n1 0 1.8173f
C866 sky130_fd_sc_hs__and2_1_3.B.t5 0 0.07168f
C867 sky130_fd_sc_hs__and2_1_3.B.t2 0 0.04295f
C868 sky130_fd_sc_hs__and2_1_3.B.n2 0 0.12323f
C869 sky130_fd_sc_hs__and2_1_3.B.n3 0 0.06337f
C870 sky130_fd_sc_hs__and2_1_3.B.n4 0 2.60372f
C871 sky130_fd_sc_hs__and2_1_3.B.t7 0 0.07765f
C872 sky130_fd_sc_hs__and2_1_3.B.t4 0 0.04659f
C873 sky130_fd_sc_hs__and2_1_3.B.n5 0 0.19022f
C874 sky130_fd_sc_hs__and2_1_3.B.t6 0 0.07765f
C875 sky130_fd_sc_hs__and2_1_3.B.t3 0 0.05254f
C876 sky130_fd_sc_hs__and2_1_3.B.n6 0 0.11777f
C877 sky130_fd_sc_hs__and2_1_3.B.n7 0 0.07853f
C878 sky130_fd_sc_hs__and2_1_3.B.t1 0 0.19185f
C879 sky130_fd_sc_hs__and2_1_3.B.n8 0 0.11215f
C880 sky130_fd_sc_hs__xor2_1_4.X.t1 0 0.05165f
C881 sky130_fd_sc_hs__xor2_1_4.X.n0 0 0.07748f
C882 sky130_fd_sc_hs__xor2_1_4.X.n1 0 0.04105f
C883 sky130_fd_sc_hs__xor2_1_4.X.n2 0 1.11518f
C884 sky130_fd_sc_hs__xor2_1_4.X.t0 0 0.17127f
C885 sky130_fd_sc_hs__xor2_1_4.X.n3 0 1.71719f
C886 sky130_fd_sc_hs__xor2_1_4.X.t4 0 0.04805f
C887 sky130_fd_sc_hs__xor2_1_4.X.n4 0 0.13516f
C888 sky130_fd_sc_hs__xor2_1_4.X.t3 0 0.02608f
C889 sky130_fd_sc_hs__xor2_1_4.X.n5 0 0.13265f
C890 sky130_fd_sc_hs__xor2_1_4.X.t2 0 0.02583f
C891 a_10122_n141.t0 0 0.02163f
C892 a_10122_n141.t1 0 0.02163f
C893 sky130_fd_sc_hs__nor2b_1_4.Y.t0 0 0.02709f
C894 sky130_fd_sc_hs__nor2b_1_4.Y.n0 0 0.14827f
C895 sky130_fd_sc_hs__nor2b_1_4.Y.n1 0 0.02934f
C896 sky130_fd_sc_hs__nor2b_1_4.Y.n2 0 0.17461f
C897 sky130_fd_sc_hs__nor2b_1_4.Y.t2 0 0.0454f
C898 sky130_fd_sc_hs__nor2b_1_4.Y.n3 0 0.04258f
C899 sky130_fd_sc_hs__nor2b_1_4.Y.n4 0 0.18667f
C900 sky130_fd_sc_hs__nor2b_1_4.Y.t4 0 0.0695f
C901 sky130_fd_sc_hs__nor2b_1_4.Y.n5 0 0.23233f
C902 sky130_fd_sc_hs__nor2b_1_4.Y.t3 0 0.07557f
C903 sky130_fd_sc_hs__nor2b_1_4.Y.n6 0 0.02934f
C904 sky130_fd_sc_hs__nor2b_1_4.Y.t1 0 0.04161f
C905 a_10530_n141.t0 0 0.16337f
C906 a_10530_n141.t5 0 0.1113f
C907 a_10530_n141.t3 0 0.19133f
C908 a_10530_n141.n0 0 0.35349f
C909 a_10530_n141.n1 0 0.24794f
C910 a_10530_n141.n2 0 0.51154f
C911 a_10530_n141.t2 0 0.15027f
C912 a_10530_n141.t4 0 0.14934f
C913 a_10530_n141.n3 0 0.77063f
C914 a_10530_n141.t1 0 0.19824f
C915 a_11037_n51.t0 0 0.00423f
C916 a_11037_n51.t5 0 0.07499f
C917 a_11037_n51.t4 0 0.02682f
C918 a_11037_n51.n0 0 0.1588f
C919 a_11037_n51.t2 0 0.03718f
C920 a_11037_n51.t1 0 0.09178f
C921 a_11037_n51.n1 0 0.13924f
C922 a_11037_n51.n2 0 0.28611f
C923 a_11037_n51.t3 0 0.03214f
C924 a_11037_n51.n3 0 0.09491f
C925 a_10885_n46.n0 0 0.01485f
C926 a_10885_n46.t0 0 0.00495f
C927 a_10885_n46.n1 0 0.10543f
C928 a_10885_n46.t1 0 0.0201f
C929 a_10885_n46.t3 0 0.0447f
C930 a_10885_n46.n2 0 0.06486f
C931 a_10885_n46.n3 0 0.45645f
C932 a_10885_n46.t4 0 0.07855f
C933 a_10885_n46.t5 0 0.06237f
C934 a_10885_n46.n4 0 0.23641f
C935 a_10885_n46.t2 0 0.02267f
C936 a_10885_n46.n5 0 0.0302f
C937 a_11534_n195.t1 0 0.11425f
C938 a_11534_n195.t4 0 0.06277f
C939 a_11534_n195.t2 0 0.04478f
C940 a_11534_n195.n0 0 0.09776f
C941 a_11534_n195.n1 0 0.22466f
C942 a_11534_n195.n2 0 0.17758f
C943 a_11534_n195.t5 0 0.03842f
C944 a_11534_n195.t3 0 0.04332f
C945 a_11534_n195.n3 0 0.27195f
C946 a_11534_n195.t0 0 0.10926f
C947 a_11983_n397.t1 0 0.14134f
C948 a_11983_n397.t0 0 0.10708f
C949 a_11983_n397.t3 0 0.05987f
C950 a_11983_n397.t2 0 0.041f
C951 a_11983_n397.n0 0 0.1298f
C952 a_11983_n397.n1 0 0.40801f
C953 a_12463_n435.t1 0 0.11354f
C954 a_12463_n435.t7 0 0.07246f
C955 a_12463_n435.t5 0 0.04312f
C956 a_12463_n435.n0 0 0.11806f
C957 a_12463_n435.n1 0 0.30003f
C958 a_12463_n435.t0 0 0.21765f
C959 a_12463_n435.t6 0 0.03778f
C960 a_12463_n435.t3 0 0.0471f
C961 a_12463_n435.n2 0 0.17528f
C962 a_12463_n435.n3 0 0.58727f
C963 a_12463_n435.t2 0 0.22179f
C964 a_12463_n435.t4 0 0.12907f
C965 a_12463_n435.n4 0 0.40149f
C966 a_10778_n6.n0 0 0.01962f
C967 a_10778_n6.t0 0 0.0064f
C968 a_10778_n6.t2 0 0.01555f
C969 a_10778_n6.n1 0 0.08573f
C970 a_10778_n6.t3 0 0.02643f
C971 a_10778_n6.t1 0 0.02767f
C972 a_10778_n6.n2 0 0.21215f
C973 a_10778_n6.n3 0 0.01995f
C974 a_10992_n6.t0 0 0.00454f
C975 a_10992_n6.t1 0 0.00454f
C976 a_8943_n408.t0 0 0.00368f
C977 a_8943_n408.t1 0 0.00368f
C978 a_9380_n385.t0 0 0.00549f
C979 a_9380_n385.t1 0 0.00549f
C980 a_11335_n85.t2 0 0.02861f
C981 a_11335_n85.n0 0 0.07721f
C982 a_11335_n85.t1 0 0.03386f
C983 a_11335_n85.t3 0 0.02802f
C984 a_11335_n85.n1 0 0.11216f
C985 a_11335_n85.n2 0 0.39133f
C986 a_11335_n85.t5 0 0.05906f
C987 a_11335_n85.t4 0 0.04121f
C988 a_11335_n85.n3 0 0.15602f
C989 a_11335_n85.t0 0 0.03721f
C990 a_11442_n1.t0 0 0.00932f
C991 a_11442_n1.t1 0 0.00932f
C992 sky130_fd_sc_hs__xor2_1_4.B.t1 0 0.11919f
C993 sky130_fd_sc_hs__xor2_1_4.B.n0 0 0.06764f
C994 sky130_fd_sc_hs__xor2_1_4.B.n1 0 2.52078f
C995 sky130_fd_sc_hs__xor2_1_4.B.t7 0 0.09303f
C996 sky130_fd_sc_hs__xor2_1_4.B.t4 0 0.05582f
C997 sky130_fd_sc_hs__xor2_1_4.B.n2 0 0.22791f
C998 sky130_fd_sc_hs__xor2_1_4.B.t6 0 0.09304f
C999 sky130_fd_sc_hs__xor2_1_4.B.t3 0 0.06295f
C1000 sky130_fd_sc_hs__xor2_1_4.B.n3 0 0.1411f
C1001 sky130_fd_sc_hs__xor2_1_4.B.n4 0 0.07795f
C1002 sky130_fd_sc_hs__xor2_1_4.B.t5 0 0.08589f
C1003 sky130_fd_sc_hs__xor2_1_4.B.t2 0 0.05146f
C1004 sky130_fd_sc_hs__xor2_1_4.B.n5 0 0.1477f
C1005 sky130_fd_sc_hs__xor2_1_4.B.n6 0 0.08269f
C1006 sky130_fd_sc_hs__xor2_1_4.B.n7 0 3.4953f
C1007 sky130_fd_sc_hs__xor2_1_4.B.t0 0 0.22264f
C1008 sky130_fd_sc_hs__xor2_1_4.B.n8 0 0.1509f
C1009 sky130_fd_sc_hs__xor2_1_5.X.t1 0 0.04524f
C1010 sky130_fd_sc_hs__xor2_1_5.X.n0 0 0.06786f
C1011 sky130_fd_sc_hs__xor2_1_5.X.n1 0 0.03595f
C1012 sky130_fd_sc_hs__xor2_1_5.X.n2 0 1.48836f
C1013 sky130_fd_sc_hs__xor2_1_5.X.t4 0 0.04208f
C1014 sky130_fd_sc_hs__xor2_1_5.X.n3 0 0.11839f
C1015 sky130_fd_sc_hs__xor2_1_5.X.t3 0 0.02284f
C1016 sky130_fd_sc_hs__xor2_1_5.X.t0 0 0.19742f
C1017 sky130_fd_sc_hs__xor2_1_5.X.n4 0 1.72562f
C1018 sky130_fd_sc_hs__xor2_1_5.X.n5 0 0.06863f
C1019 sky130_fd_sc_hs__xor2_1_5.X.t2 0 0.02262f
C1020 a_12234_n141.t0 0 0.02169f
C1021 a_12234_n141.t1 0 0.02169f
C1022 sky130_fd_sc_hs__dfxtp_1_5.D.t1 0 0.04729f
C1023 sky130_fd_sc_hs__dfxtp_1_5.D.n0 0 0.16852f
C1024 sky130_fd_sc_hs__dfxtp_1_5.D.n1 0 0.03597f
C1025 sky130_fd_sc_hs__dfxtp_1_5.D.n2 0 0.19845f
C1026 sky130_fd_sc_hs__dfxtp_1_5.D.t0 0 0.0516f
C1027 sky130_fd_sc_hs__dfxtp_1_5.D.n3 0 0.04839f
C1028 sky130_fd_sc_hs__dfxtp_1_5.D.n4 0 0.24059f
C1029 sky130_fd_sc_hs__dfxtp_1_5.D.t4 0 0.07899f
C1030 sky130_fd_sc_hs__dfxtp_1_5.D.n5 0 0.22986f
C1031 sky130_fd_sc_hs__dfxtp_1_5.D.t3 0 0.08589f
C1032 sky130_fd_sc_hs__dfxtp_1_5.D.n6 0 0.03335f
C1033 sky130_fd_sc_hs__dfxtp_1_5.D.t2 0 0.03079f
C1034 a_12642_n141.t1 0 0.16569f
C1035 a_12642_n141.t5 0 0.11288f
C1036 a_12642_n141.t3 0 0.19405f
C1037 a_12642_n141.n0 0 0.35852f
C1038 a_12642_n141.n1 0 0.25147f
C1039 a_12642_n141.n2 0 0.51881f
C1040 a_12642_n141.t2 0 0.15241f
C1041 a_12642_n141.t4 0 0.15146f
C1042 a_12642_n141.n3 0 0.78159f
C1043 a_12642_n141.t0 0 0.20106f
C1044 a_13149_n51.t2 0 0.03232f
C1045 a_13149_n51.t5 0 0.07542f
C1046 a_13149_n51.t4 0 0.02697f
C1047 a_13149_n51.n0 0 0.15969f
C1048 a_13149_n51.t1 0 0.03739f
C1049 a_13149_n51.t0 0 0.0923f
C1050 a_13149_n51.n1 0 0.14003f
C1051 a_13149_n51.n2 0 0.28772f
C1052 a_13149_n51.t3 0 0.00426f
C1053 a_13149_n51.n3 0 0.09544f
C1054 a_12997_n46.n0 0 0.01543f
C1055 a_12997_n46.t0 0 0.00514f
C1056 a_12997_n46.n1 0 0.10953f
C1057 a_12997_n46.t2 0 0.02088f
C1058 a_12997_n46.t1 0 0.04644f
C1059 a_12997_n46.n2 0 0.06739f
C1060 a_12997_n46.n3 0 0.4742f
C1061 a_12997_n46.t4 0 0.08161f
C1062 a_12997_n46.t5 0 0.06479f
C1063 a_12997_n46.n4 0 0.24561f
C1064 a_12997_n46.t3 0 0.02355f
C1065 a_12997_n46.n5 0 0.03137f
C1066 a_13646_n195.t1 0 0.10876f
C1067 a_13646_n195.t4 0 0.05976f
C1068 a_13646_n195.t2 0 0.04263f
C1069 a_13646_n195.n0 0 0.09307f
C1070 a_13646_n195.n1 0 0.21388f
C1071 a_13646_n195.n2 0 0.16905f
C1072 a_13646_n195.t5 0 0.03657f
C1073 a_13646_n195.t3 0 0.04124f
C1074 a_13646_n195.n3 0 0.2589f
C1075 a_13646_n195.t0 0 0.10401f
C1076 a_14095_n397.t1 0 0.13114f
C1077 a_14095_n397.t0 0 0.09935f
C1078 a_14095_n397.t3 0 0.05555f
C1079 a_14095_n397.t2 0 0.03804f
C1080 a_14095_n397.n0 0 0.12043f
C1081 a_14095_n397.n1 0 0.37855f
C1082 a_14575_n435.t1 0 0.11416f
C1083 a_14575_n435.t7 0 0.07285f
C1084 a_14575_n435.t5 0 0.04336f
C1085 a_14575_n435.n0 0 0.1187f
C1086 a_14575_n435.n1 0 0.30165f
C1087 a_14575_n435.t0 0 0.21883f
C1088 a_14575_n435.t6 0 0.03799f
C1089 a_14575_n435.t3 0 0.04735f
C1090 a_14575_n435.n2 0 0.17623f
C1091 a_14575_n435.n3 0 0.59044f
C1092 a_14575_n435.t2 0 0.22299f
C1093 a_14575_n435.t4 0 0.12977f
C1094 a_14575_n435.n4 0 0.40366f
C1095 a_12890_n6.n0 0 0.02099f
C1096 a_12890_n6.t0 0 0.00685f
C1097 a_12890_n6.t1 0 0.01663f
C1098 a_12890_n6.n1 0 0.0917f
C1099 a_12890_n6.t2 0 0.02827f
C1100 a_12890_n6.t3 0 0.02959f
C1101 a_12890_n6.n2 0 0.22692f
C1102 a_12890_n6.n3 0 0.02134f
C1103 a_13104_n6.t0 0 0.00456f
C1104 a_13104_n6.t1 0 0.00456f
C1105 a_11055_n408.t0 0 0.00322f
C1106 a_11055_n408.t1 0 0.00322f
C1107 a_11492_n385.t0 0 0.00549f
C1108 a_11492_n385.t1 0 0.00549f
C1109 a_13447_n85.t1 0 0.02787f
C1110 a_13447_n85.t0 0 0.03368f
C1111 a_13447_n85.t3 0 0.03701f
C1112 a_13447_n85.t2 0 0.02845f
C1113 a_13447_n85.n0 0 0.07679f
C1114 a_13447_n85.n1 0 0.38922f
C1115 a_13447_n85.t5 0 0.05874f
C1116 a_13447_n85.t4 0 0.04099f
C1117 a_13447_n85.n2 0 0.15518f
C1118 a_13447_n85.n3 0 0.11156f
C1119 a_13554_n1.t0 0 0.00912f
C1120 a_13554_n1.t1 0 0.00912f
C1121 sky130_fd_sc_hs__xor2_1_5.B.t1 0 0.12355f
C1122 sky130_fd_sc_hs__xor2_1_5.B.n0 0 0.07011f
C1123 sky130_fd_sc_hs__xor2_1_5.B.n1 0 2.35455f
C1124 sky130_fd_sc_hs__xor2_1_5.B.n2 0 0.08033f
C1125 sky130_fd_sc_hs__xor2_1_5.B.t5 0 0.08903f
C1126 sky130_fd_sc_hs__xor2_1_5.B.t2 0 0.05335f
C1127 sky130_fd_sc_hs__xor2_1_5.B.n3 0 0.15305f
C1128 sky130_fd_sc_hs__xor2_1_5.B.t7 0 0.09644f
C1129 sky130_fd_sc_hs__xor2_1_5.B.t4 0 0.05787f
C1130 sky130_fd_sc_hs__xor2_1_5.B.n4 0 0.23625f
C1131 sky130_fd_sc_hs__xor2_1_5.B.t6 0 0.09644f
C1132 sky130_fd_sc_hs__xor2_1_5.B.t3 0 0.06525f
C1133 sky130_fd_sc_hs__xor2_1_5.B.n5 0 0.14627f
C1134 sky130_fd_sc_hs__xor2_1_5.B.n6 0 0.0534f
C1135 sky130_fd_sc_hs__xor2_1_5.B.n7 0 0.04571f
C1136 sky130_fd_sc_hs__xor2_1_5.B.n8 0 3.47912f
C1137 sky130_fd_sc_hs__xor2_1_5.B.t0 0 0.23036f
C1138 sky130_fd_sc_hs__xor2_1_5.B.n9 0 0.15921f
C1139 sky130_fd_sc_hs__xor2_1_6.X.t0 0 0.03854f
C1140 sky130_fd_sc_hs__xor2_1_6.X.n0 0 0.11561f
C1141 sky130_fd_sc_hs__xor2_1_6.X.n1 0 0.06125f
C1142 sky130_fd_sc_hs__xor2_1_6.X.n2 0 2.17154f
C1143 sky130_fd_sc_hs__xor2_1_6.X.t1 0 0.25561f
C1144 sky130_fd_sc_hs__xor2_1_6.X.t4 0 0.07169f
C1145 sky130_fd_sc_hs__xor2_1_6.X.n3 0 0.20168f
C1146 sky130_fd_sc_hs__xor2_1_6.X.t3 0 0.03891f
C1147 sky130_fd_sc_hs__xor2_1_6.X.n4 0 2.91626f
C1148 sky130_fd_sc_hs__xor2_1_6.X.n5 0 0.19764f
C1149 sky130_fd_sc_hs__xor2_1_6.X.t2 0 0.07707f
C1150 a_14346_n141.t0 0 0.02165f
C1151 a_14346_n141.t1 0 0.02165f
C1152 sky130_fd_sc_hs__dfxtp_1_6.D.t0 0 0.02602f
C1153 sky130_fd_sc_hs__dfxtp_1_6.D.n0 0 0.1424f
C1154 sky130_fd_sc_hs__dfxtp_1_6.D.n1 0 0.02873f
C1155 sky130_fd_sc_hs__dfxtp_1_6.D.n2 0 0.16769f
C1156 sky130_fd_sc_hs__dfxtp_1_6.D.t2 0 0.0436f
C1157 sky130_fd_sc_hs__dfxtp_1_6.D.n3 0 0.04089f
C1158 sky130_fd_sc_hs__dfxtp_1_6.D.n4 0 0.1545f
C1159 sky130_fd_sc_hs__dfxtp_1_6.D.t4 0 0.06679f
C1160 sky130_fd_sc_hs__dfxtp_1_6.D.t3 0 0.07258f
C1161 sky130_fd_sc_hs__dfxtp_1_6.D.n5 0 0.0277f
C1162 sky130_fd_sc_hs__dfxtp_1_6.D.n6 0 0.20313f
C1163 sky130_fd_sc_hs__dfxtp_1_6.D.t1 0 0.03996f
C1164 a_14754_n141.t0 0 0.1522f
C1165 a_14754_n141.t5 0 0.10369f
C1166 a_14754_n141.t3 0 0.17825f
C1167 a_14754_n141.n0 0 0.32933f
C1168 a_14754_n141.n1 0 0.231f
C1169 a_14754_n141.n2 0 0.47658f
C1170 a_14754_n141.t2 0 0.14f
C1171 a_14754_n141.t4 0 0.13913f
C1172 a_14754_n141.n3 0 0.71796f
C1173 a_14754_n141.t1 0 0.18469f
C1174 a_15261_n51.t0 0 0.00404f
C1175 a_15261_n51.t5 0 0.07154f
C1176 a_15261_n51.t4 0 0.02559f
C1177 a_15261_n51.n0 0 0.15148f
C1178 a_15261_n51.t2 0 0.03546f
C1179 a_15261_n51.t1 0 0.08755f
C1180 a_15261_n51.n1 0 0.13283f
C1181 a_15261_n51.n2 0 0.27292f
C1182 a_15261_n51.t3 0 0.03065f
C1183 a_15261_n51.n3 0 0.09053f
C1184 a_15109_n46.t0 0 0.01939f
C1185 a_15109_n46.t1 0 0.04313f
C1186 a_15109_n46.t4 0 0.07579f
C1187 a_15109_n46.t5 0 0.06018f
C1188 a_15109_n46.n0 0 0.22812f
C1189 a_15109_n46.t2 0 0.02187f
C1190 a_15109_n46.t3 0 0.02873f
C1191 a_15109_n46.n1 0 0.12124f
C1192 a_15109_n46.n2 0 0.44044f
C1193 a_15109_n46.n3 0 0.06259f
C1194 a_15758_n195.t1 0 0.09511f
C1195 a_15758_n195.t4 0 0.05226f
C1196 a_15758_n195.t2 0 0.03728f
C1197 a_15758_n195.n0 0 0.08138f
C1198 a_15758_n195.n1 0 0.18702f
C1199 a_15758_n195.n2 0 0.14782f
C1200 a_15758_n195.t5 0 0.03198f
C1201 a_15758_n195.t3 0 0.03606f
C1202 a_15758_n195.n3 0 0.22639f
C1203 a_15758_n195.t0 0 0.09095f
C1204 a_15002_n6.n0 0 0.01905f
C1205 a_15002_n6.t0 0 0.00622f
C1206 a_15002_n6.t1 0 0.0151f
C1207 a_15002_n6.n1 0 0.08324f
C1208 a_15002_n6.t3 0 0.02566f
C1209 a_15002_n6.t2 0 0.02686f
C1210 a_15002_n6.n2 0 0.20599f
C1211 a_15002_n6.n3 0 0.01937f
C1212 a_15216_n6.t0 0 0.00434f
C1213 a_15216_n6.t1 0 0.00434f
C1214 a_13167_n408.t0 0 0.00317f
C1215 a_13167_n408.t1 0 0.00317f
C1216 a_13604_n385.t0 0 0.00542f
C1217 a_13604_n385.t1 0 0.00542f
C1218 a_15559_n85.t2 0 0.02478f
C1219 a_15559_n85.t1 0 0.02995f
C1220 a_15559_n85.t0 0 0.03291f
C1221 a_15559_n85.t3 0 0.0253f
C1222 a_15559_n85.n0 0 0.06828f
C1223 a_15559_n85.n1 0 0.34609f
C1224 a_15559_n85.t5 0 0.05223f
C1225 a_15559_n85.t4 0 0.03645f
C1226 a_15559_n85.n2 0 0.13799f
C1227 a_15559_n85.n3 0 0.0992f
C1228 a_15666_n1.t0 0 0.00856f
C1229 a_15666_n1.t1 0 0.00856f
C1230 sky130_fd_sc_hs__and2_1_6.B.t1 0 0.10692f
C1231 sky130_fd_sc_hs__and2_1_6.B.n0 0 0.02783f
C1232 sky130_fd_sc_hs__and2_1_6.B.t0 0 0.28124f
C1233 sky130_fd_sc_hs__and2_1_6.B.n1 0 1.77729f
C1234 sky130_fd_sc_hs__and2_1_6.B.t5 0 0.07705f
C1235 sky130_fd_sc_hs__and2_1_6.B.t2 0 0.04617f
C1236 sky130_fd_sc_hs__and2_1_6.B.n2 0 0.13251f
C1237 sky130_fd_sc_hs__and2_1_6.B.n3 0 0.07002f
C1238 sky130_fd_sc_hs__and2_1_6.B.n4 0 3.44121f
C1239 sky130_fd_sc_hs__and2_1_6.B.t7 0 0.08346f
C1240 sky130_fd_sc_hs__and2_1_6.B.t4 0 0.05008f
C1241 sky130_fd_sc_hs__and2_1_6.B.n5 0 0.20446f
C1242 sky130_fd_sc_hs__and2_1_6.B.t6 0 0.08347f
C1243 sky130_fd_sc_hs__and2_1_6.B.t3 0 0.05647f
C1244 sky130_fd_sc_hs__and2_1_6.B.n6 0 0.12659f
C1245 sky130_fd_sc_hs__and2_1_6.B.n7 0 0.04621f
C1246 sky130_fd_sc_hs__and2_1_6.B.n8 0 0.03965f
C1247 sky130_fd_sc_hs__and2_1_6.B.n9 0 0.04172f
C1248 sky130_fd_sc_hs__and2_1_6.B.n10 0 0.02705f
C1249 sky130_fd_sc_hs__and2_1_6.B.n11 0 0.3259f
C1250 a_15279_n408.t0 0 0.00322f
C1251 a_15279_n408.t1 0 0.00322f
C1252 a_15716_n385.t0 0 0.00503f
C1253 a_15716_n385.t1 0 0.00503f
C1254 a_1626_n1188.t0 0 0.0487f
C1255 a_1626_n1188.n0 0 0.11729f
C1256 a_1626_n1188.t1 0 0.11816f
C1257 a_1626_n1188.t4 0 0.05363f
C1258 a_1626_n1188.t3 0 0.0348f
C1259 a_1626_n1188.n1 0 0.14095f
C1260 a_1626_n1188.n2 0 0.4877f
C1261 a_1626_n1188.t2 0 0.04582f
C1262 a_2254_n1177.t2 0 0.10057f
C1263 a_2254_n1177.t4 0 0.05558f
C1264 a_2254_n1177.t3 0 0.03558f
C1265 a_2254_n1177.n0 0 0.10369f
C1266 a_2254_n1177.n1 0 0.42299f
C1267 a_2254_n1177.n2 0 0.07264f
C1268 a_2254_n1177.t1 0 0.03711f
C1269 a_2254_n1177.t0 0 0.02783f
C1270 sky130_fd_sc_hs__and2_1_0.X.t1 0 0.04597f
C1271 sky130_fd_sc_hs__and2_1_0.X.n0 0 0.05863f
C1272 sky130_fd_sc_hs__and2_1_0.X.n1 0 0.04686f
C1273 sky130_fd_sc_hs__and2_1_0.X.t2 0 0.07193f
C1274 sky130_fd_sc_hs__and2_1_0.X.t5 0 0.04796f
C1275 sky130_fd_sc_hs__and2_1_0.X.n2 0 0.05291f
C1276 sky130_fd_sc_hs__and2_1_0.X.n3 0 0.04845f
C1277 sky130_fd_sc_hs__and2_1_0.X.t4 0 0.06839f
C1278 sky130_fd_sc_hs__and2_1_0.X.t3 0 0.09256f
C1279 sky130_fd_sc_hs__and2_1_0.X.t6 0 0.05358f
C1280 sky130_fd_sc_hs__and2_1_0.X.t7 0 0.03337f
C1281 sky130_fd_sc_hs__and2_1_0.X.n4 0 0.08063f
C1282 sky130_fd_sc_hs__and2_1_0.X.n5 0 0.30181f
C1283 sky130_fd_sc_hs__and2_1_0.X.n6 0 0.02059f
C1284 sky130_fd_sc_hs__and2_1_0.X.n7 0 0.06964f
C1285 sky130_fd_sc_hs__and2_1_0.X.t0 0 0.02368f
C1286 sky130_fd_sc_hs__and2_1_0.X.n8 0 0.02059f
C1287 sky130_fd_sc_hs__and2_1_0.X.n9 0 0.067f
C1288 a_2872_n1188.t1 0 0.04626f
C1289 a_2872_n1188.n0 0 0.11842f
C1290 a_2872_n1188.t0 0 0.11929f
C1291 a_2872_n1188.t4 0 0.05414f
C1292 a_2872_n1188.t3 0 0.03513f
C1293 a_2872_n1188.n1 0 0.1423f
C1294 a_2872_n1188.n2 0 0.49239f
C1295 a_2872_n1188.t2 0 0.04917f
C1296 a_3502_n1177.t2 0 0.10303f
C1297 a_3502_n1177.t4 0 0.05693f
C1298 a_3502_n1177.t3 0 0.03645f
C1299 a_3502_n1177.n0 0 0.10622f
C1300 a_3502_n1177.n1 0 0.43332f
C1301 a_3502_n1177.n2 0 0.07441f
C1302 a_3502_n1177.t0 0 0.03802f
C1303 a_3502_n1177.t1 0 0.02851f
C1304 sky130_fd_sc_hs__and2_1_1.X.t1 0 0.04546f
C1305 sky130_fd_sc_hs__and2_1_1.X.n0 0 0.05832f
C1306 sky130_fd_sc_hs__and2_1_1.X.n1 0 0.04695f
C1307 sky130_fd_sc_hs__and2_1_1.X.t2 0 0.07114f
C1308 sky130_fd_sc_hs__and2_1_1.X.t5 0 0.04743f
C1309 sky130_fd_sc_hs__and2_1_1.X.n2 0 0.05242f
C1310 sky130_fd_sc_hs__and2_1_1.X.n3 0 0.04835f
C1311 sky130_fd_sc_hs__and2_1_1.X.t4 0 0.06764f
C1312 sky130_fd_sc_hs__and2_1_1.X.t3 0 0.09153f
C1313 sky130_fd_sc_hs__and2_1_1.X.t6 0 0.05299f
C1314 sky130_fd_sc_hs__and2_1_1.X.t7 0 0.033f
C1315 sky130_fd_sc_hs__and2_1_1.X.n4 0 0.07973f
C1316 sky130_fd_sc_hs__and2_1_1.X.n5 0 0.31047f
C1317 sky130_fd_sc_hs__and2_1_1.X.n6 0 0.02037f
C1318 sky130_fd_sc_hs__and2_1_1.X.n7 0 0.06887f
C1319 sky130_fd_sc_hs__and2_1_1.X.t0 0 0.02342f
C1320 sky130_fd_sc_hs__and2_1_1.X.n8 0 0.02037f
C1321 sky130_fd_sc_hs__and2_1_1.X.n9 0 0.06626f
C1322 a_4116_n1188.t1 0 0.04952f
C1323 a_4116_n1188.n0 0 0.11926f
C1324 a_4116_n1188.t0 0 0.12014f
C1325 a_4116_n1188.t4 0 0.05453f
C1326 a_4116_n1188.t3 0 0.03538f
C1327 a_4116_n1188.n1 0 0.14331f
C1328 a_4116_n1188.n2 0 0.49588f
C1329 a_4116_n1188.t2 0 0.04659f
C1330 a_4746_n1177.t0 0 0.10313f
C1331 a_4746_n1177.t4 0 0.05699f
C1332 a_4746_n1177.t3 0 0.03649f
C1333 a_4746_n1177.n0 0 0.10633f
C1334 a_4746_n1177.n1 0 0.43377f
C1335 a_4746_n1177.n2 0 0.07449f
C1336 a_4746_n1177.t2 0 0.03806f
C1337 a_4746_n1177.t1 0 0.02854f
C1338 sky130_fd_sc_hs__and2_1_2.X.t1 0 0.04656f
C1339 sky130_fd_sc_hs__and2_1_2.X.n0 0 0.06088f
C1340 sky130_fd_sc_hs__and2_1_2.X.n1 0 0.30558f
C1341 sky130_fd_sc_hs__and2_1_2.X.n2 0 0.05f
C1342 sky130_fd_sc_hs__and2_1_2.X.t4 0 0.06924f
C1343 sky130_fd_sc_hs__and2_1_2.X.t3 0 0.09371f
C1344 sky130_fd_sc_hs__and2_1_2.X.t6 0 0.05425f
C1345 sky130_fd_sc_hs__and2_1_2.X.t7 0 0.03378f
C1346 sky130_fd_sc_hs__and2_1_2.X.n3 0 0.08163f
C1347 sky130_fd_sc_hs__and2_1_2.X.n4 0 0.04549f
C1348 sky130_fd_sc_hs__and2_1_2.X.t2 0 0.07283f
C1349 sky130_fd_sc_hs__and2_1_2.X.t5 0 0.04856f
C1350 sky130_fd_sc_hs__and2_1_2.X.n5 0 0.05433f
C1351 sky130_fd_sc_hs__and2_1_2.X.n6 0 0.02085f
C1352 sky130_fd_sc_hs__and2_1_2.X.n7 0 0.07051f
C1353 sky130_fd_sc_hs__and2_1_2.X.t0 0 0.02398f
C1354 sky130_fd_sc_hs__and2_1_2.X.n8 0 0.02085f
C1355 sky130_fd_sc_hs__and2_1_2.X.n9 0 0.0675f
C1356 a_5362_n1188.t0 0 0.04807f
C1357 a_5362_n1188.n0 0 0.12305f
C1358 a_5362_n1188.t2 0 0.12396f
C1359 a_5362_n1188.t4 0 0.05626f
C1360 a_5362_n1188.t3 0 0.0365f
C1361 a_5362_n1188.n1 0 0.14787f
C1362 a_5362_n1188.n2 0 0.51163f
C1363 a_5362_n1188.t1 0 0.05109f
C1364 a_5990_n1177.t2 0 0.10758f
C1365 a_5990_n1177.t4 0 0.05945f
C1366 a_5990_n1177.t3 0 0.03806f
C1367 a_5990_n1177.n0 0 0.11091f
C1368 a_5990_n1177.n1 0 0.45246f
C1369 a_5990_n1177.n2 0 0.0777f
C1370 a_5990_n1177.t0 0 0.03969f
C1371 a_5990_n1177.t1 0 0.02977f
C1372 sky130_fd_sc_hs__and2_1_3.X.t1 0 0.0488f
C1373 sky130_fd_sc_hs__and2_1_3.X.n0 0 0.06137f
C1374 sky130_fd_sc_hs__and2_1_3.X.n1 0 0.04974f
C1375 sky130_fd_sc_hs__and2_1_3.X.t2 0 0.07635f
C1376 sky130_fd_sc_hs__and2_1_3.X.t5 0 0.05091f
C1377 sky130_fd_sc_hs__and2_1_3.X.n2 0 0.05621f
C1378 sky130_fd_sc_hs__and2_1_3.X.n3 0 0.05253f
C1379 sky130_fd_sc_hs__and2_1_3.X.t4 0 0.07259f
C1380 sky130_fd_sc_hs__and2_1_3.X.t3 0 0.09825f
C1381 sky130_fd_sc_hs__and2_1_3.X.t6 0 0.05688f
C1382 sky130_fd_sc_hs__and2_1_3.X.t7 0 0.03542f
C1383 sky130_fd_sc_hs__and2_1_3.X.n4 0 0.08558f
C1384 sky130_fd_sc_hs__and2_1_3.X.n5 0 0.32598f
C1385 sky130_fd_sc_hs__and2_1_3.X.n6 0 0.02186f
C1386 sky130_fd_sc_hs__and2_1_3.X.n7 0 0.07392f
C1387 sky130_fd_sc_hs__and2_1_3.X.t0 0 0.02514f
C1388 sky130_fd_sc_hs__and2_1_3.X.n8 0 0.02186f
C1389 sky130_fd_sc_hs__and2_1_3.X.n9 0 0.07112f
C1390 a_6608_n1188.t0 0 0.05181f
C1391 a_6608_n1188.n0 0 0.13261f
C1392 a_6608_n1188.t2 0 0.13359f
C1393 a_6608_n1188.t4 0 0.06063f
C1394 a_6608_n1188.t3 0 0.03934f
C1395 a_6608_n1188.n1 0 0.15936f
C1396 a_6608_n1188.n2 0 0.55141f
C1397 a_6608_n1188.t1 0 0.05506f
C1398 a_7238_n1177.t0 0 0.10943f
C1399 a_7238_n1177.t4 0 0.06047f
C1400 a_7238_n1177.t3 0 0.03872f
C1401 a_7238_n1177.n0 0 0.11282f
C1402 a_7238_n1177.n1 0 0.46024f
C1403 a_7238_n1177.n2 0 0.07903f
C1404 a_7238_n1177.t2 0 0.04038f
C1405 a_7238_n1177.t1 0 0.03028f
C1406 sky130_fd_sc_hs__and2_1_4.X.t1 0 0.05021f
C1407 sky130_fd_sc_hs__and2_1_4.X.n0 0 0.06256f
C1408 sky130_fd_sc_hs__and2_1_4.X.n1 0 0.0505f
C1409 sky130_fd_sc_hs__and2_1_4.X.t2 0 0.07856f
C1410 sky130_fd_sc_hs__and2_1_4.X.t5 0 0.05238f
C1411 sky130_fd_sc_hs__and2_1_4.X.n2 0 0.05885f
C1412 sky130_fd_sc_hs__and2_1_4.X.n3 0 0.05349f
C1413 sky130_fd_sc_hs__and2_1_4.X.t4 0 0.0747f
C1414 sky130_fd_sc_hs__and2_1_4.X.t3 0 0.10109f
C1415 sky130_fd_sc_hs__and2_1_4.X.t6 0 0.05852f
C1416 sky130_fd_sc_hs__and2_1_4.X.t7 0 0.03644f
C1417 sky130_fd_sc_hs__and2_1_4.X.n4 0 0.08806f
C1418 sky130_fd_sc_hs__and2_1_4.X.n5 0 0.31251f
C1419 sky130_fd_sc_hs__and2_1_4.X.n6 0 0.02249f
C1420 sky130_fd_sc_hs__and2_1_4.X.n7 0 0.07606f
C1421 sky130_fd_sc_hs__and2_1_4.X.t0 0 0.02586f
C1422 sky130_fd_sc_hs__and2_1_4.X.n8 0 0.02249f
C1423 sky130_fd_sc_hs__and2_1_4.X.n9 0 0.07318f
C1424 a_7854_n1188.t0 0 0.05202f
C1425 a_7854_n1188.n0 0 0.13315f
C1426 a_7854_n1188.t2 0 0.13413f
C1427 a_7854_n1188.t4 0 0.06088f
C1428 a_7854_n1188.t3 0 0.0395f
C1429 a_7854_n1188.n1 0 0.16001f
C1430 a_7854_n1188.n2 0 0.55364f
C1431 a_7854_n1188.t1 0 0.05529f
C1432 a_8484_n1177.t0 0 0.11296f
C1433 a_8484_n1177.t4 0 0.06242f
C1434 a_8484_n1177.t3 0 0.03996f
C1435 a_8484_n1177.n0 0 0.11645f
C1436 a_8484_n1177.n1 0 0.47508f
C1437 a_8484_n1177.n2 0 0.08158f
C1438 a_8484_n1177.t1 0 0.04168f
C1439 a_8484_n1177.t2 0 0.03126f
C1440 sky130_fd_sc_hs__and2_1_5.X.t0 0 0.12615f
C1441 sky130_fd_sc_hs__and2_1_5.X.n0 0 0.03087f
C1442 sky130_fd_sc_hs__and2_1_5.X.n1 0 0.10427f
C1443 sky130_fd_sc_hs__and2_1_5.X.t1 0 0.0355f
C1444 sky130_fd_sc_hs__and2_1_5.X.n2 0 0.03087f
C1445 sky130_fd_sc_hs__and2_1_5.X.n3 0 0.08894f
C1446 sky130_fd_sc_hs__and2_1_5.X.n4 0 0.08713f
C1447 sky130_fd_sc_hs__and2_1_5.X.t4 0 0.10253f
C1448 sky130_fd_sc_hs__and2_1_5.X.t3 0 0.13876f
C1449 sky130_fd_sc_hs__and2_1_5.X.t6 0 0.08033f
C1450 sky130_fd_sc_hs__and2_1_5.X.t7 0 0.05002f
C1451 sky130_fd_sc_hs__and2_1_5.X.n5 0 0.12087f
C1452 sky130_fd_sc_hs__and2_1_5.X.n6 0 0.58638f
C1453 sky130_fd_sc_hs__and2_1_5.X.n7 0 0.07117f
C1454 sky130_fd_sc_hs__and2_1_5.X.t2 0 0.10784f
C1455 sky130_fd_sc_hs__and2_1_5.X.t5 0 0.07191f
C1456 sky130_fd_sc_hs__and2_1_5.X.n8 0 0.15642f
C1457 a_9100_n1188.t0 0 0.05558f
C1458 a_9100_n1188.n0 0 0.13385f
C1459 a_9100_n1188.t2 0 0.13484f
C1460 a_9100_n1188.t4 0 0.0612f
C1461 a_9100_n1188.t3 0 0.03971f
C1462 a_9100_n1188.n1 0 0.16084f
C1463 a_9100_n1188.n2 0 0.55654f
C1464 a_9100_n1188.t1 0 0.05229f
C1465 a_9722_n1177.t2 0 0.11404f
C1466 a_9722_n1177.t4 0 0.06302f
C1467 a_9722_n1177.t3 0 0.04035f
C1468 a_9722_n1177.n0 0 0.11757f
C1469 a_9722_n1177.n1 0 0.47964f
C1470 a_9722_n1177.n2 0 0.08237f
C1471 a_9722_n1177.t0 0 0.04208f
C1472 a_9722_n1177.t1 0 0.03156f
C1473 sky130_fd_sc_hs__and2_1_6.X.t1 0 0.05914f
C1474 sky130_fd_sc_hs__and2_1_6.X.n0 0 0.07415f
C1475 sky130_fd_sc_hs__and2_1_6.X.n1 0 0.47973f
C1476 sky130_fd_sc_hs__and2_1_6.X.n2 0 0.11122f
C1477 sky130_fd_sc_hs__and2_1_6.X.t4 0 0.08798f
C1478 sky130_fd_sc_hs__and2_1_6.X.t3 0 0.11907f
C1479 sky130_fd_sc_hs__and2_1_6.X.t6 0 0.06893f
C1480 sky130_fd_sc_hs__and2_1_6.X.t7 0 0.04292f
C1481 sky130_fd_sc_hs__and2_1_6.X.n3 0 0.10372f
C1482 sky130_fd_sc_hs__and2_1_6.X.n4 0 0.05865f
C1483 sky130_fd_sc_hs__and2_1_6.X.t2 0 0.09254f
C1484 sky130_fd_sc_hs__and2_1_6.X.t5 0 0.0617f
C1485 sky130_fd_sc_hs__and2_1_6.X.n5 0 0.06865f
C1486 sky130_fd_sc_hs__and2_1_6.X.n6 0 0.02649f
C1487 sky130_fd_sc_hs__and2_1_6.X.n7 0 0.08959f
C1488 sky130_fd_sc_hs__and2_1_6.X.t0 0 0.03046f
C1489 sky130_fd_sc_hs__and2_1_6.X.n8 0 0.02649f
C1490 sky130_fd_sc_hs__and2_1_6.X.n9 0 0.0862f
C1491 sky130_fd_sc_hs__and2_1_7.B.t1 0 0.09002f
C1492 sky130_fd_sc_hs__and2_1_7.B.n0 0 0.02746f
C1493 sky130_fd_sc_hs__and2_1_7.B.n1 0 0.29761f
C1494 sky130_fd_sc_hs__and2_1_7.B.t5 0 0.06487f
C1495 sky130_fd_sc_hs__and2_1_7.B.t2 0 0.03887f
C1496 sky130_fd_sc_hs__and2_1_7.B.n2 0 0.11173f
C1497 sky130_fd_sc_hs__and2_1_7.B.n3 0 0.06063f
C1498 sky130_fd_sc_hs__and2_1_7.B.n4 0 1.03739f
C1499 sky130_fd_sc_hs__and2_1_7.B.t7 0 0.07027f
C1500 sky130_fd_sc_hs__and2_1_7.B.t4 0 0.04217f
C1501 sky130_fd_sc_hs__and2_1_7.B.n5 0 0.17215f
C1502 sky130_fd_sc_hs__and2_1_7.B.t6 0 0.07028f
C1503 sky130_fd_sc_hs__and2_1_7.B.t3 0 0.04755f
C1504 sky130_fd_sc_hs__and2_1_7.B.n6 0 0.10658f
C1505 sky130_fd_sc_hs__and2_1_7.B.n7 0 0.06876f
C1506 sky130_fd_sc_hs__and2_1_7.B.t0 0 0.23679f
C1507 sky130_fd_sc_hs__and2_1_7.B.n8 0 0.28394f
C1508 a_10340_n1188.t1 0 0.05246f
C1509 a_10340_n1188.n0 0 0.13429f
C1510 a_10340_n1188.t0 0 0.13528f
C1511 a_10340_n1188.t4 0 0.0614f
C1512 a_10340_n1188.t3 0 0.03984f
C1513 a_10340_n1188.n1 0 0.16137f
C1514 a_10340_n1188.n2 0 0.55838f
C1515 a_10340_n1188.t2 0 0.05576f
C1516 a_10950_n1177.t0 0 0.11634f
C1517 a_10950_n1177.t4 0 0.06429f
C1518 a_10950_n1177.t3 0 0.04116f
C1519 a_10950_n1177.n0 0 0.11994f
C1520 a_10950_n1177.n1 0 0.48931f
C1521 a_10950_n1177.n2 0 0.08403f
C1522 a_10950_n1177.t1 0 0.04293f
C1523 a_10950_n1177.t2 0 0.0322f
C1524 a_11399_n1201.t1 0 0.14599f
C1525 a_11399_n1201.t0 0 0.1106f
C1526 a_11399_n1201.t3 0 0.06184f
C1527 a_11399_n1201.t2 0 0.04235f
C1528 a_11399_n1201.n0 0 0.13407f
C1529 a_11399_n1201.n1 0 0.42142f
C1530 a_11879_n1239.t1 0 0.12065f
C1531 a_11879_n1239.t7 0 0.077f
C1532 a_11879_n1239.t5 0 0.04582f
C1533 a_11879_n1239.n0 0 0.12545f
C1534 a_11879_n1239.n1 0 0.31881f
C1535 a_11879_n1239.t0 0 0.23128f
C1536 a_11879_n1239.t6 0 0.04015f
C1537 a_11879_n1239.t3 0 0.05005f
C1538 a_11879_n1239.n2 0 0.18626f
C1539 a_11879_n1239.n3 0 0.62404f
C1540 a_11879_n1239.t2 0 0.23568f
C1541 a_11879_n1239.t4 0 0.13715f
C1542 a_11879_n1239.n4 0 0.42663f
C1543 a_1590_n921.t0 0 0.01189f
C1544 a_1590_n921.t1 0 0.01189f
C1545 a_1787_n945.t0 0 0.04141f
C1546 a_1787_n945.n0 0 0.19126f
C1547 a_1787_n945.t2 0 0.23738f
C1548 a_1787_n945.t1 0 0.03106f
C1549 a_2836_n921.t0 0 0.01167f
C1550 a_2836_n921.t1 0 0.01167f
C1551 a_3033_n945.t0 0 0.03091f
C1552 a_3033_n945.n0 0 0.19031f
C1553 a_3033_n945.t2 0 0.23619f
C1554 a_3033_n945.t1 0 0.04121f
C1555 a_1887_n1226.t0 0 0.00779f
C1556 a_1887_n1226.t1 0 0.00779f
C1557 a_2341_n1177.n0 0 0.00125f
C1558 a_2341_n1177.t0 0 0
C1559 a_2341_n1177.t1 0 0.00733f
C1560 a_2341_n1177.n1 0 0.01391f
C1561 a_4080_n921.t0 0 0.01223f
C1562 a_4080_n921.t1 0 0.01223f
C1563 a_4277_n945.t0 0 0.03088f
C1564 a_4277_n945.n0 0 0.19017f
C1565 a_4277_n945.t2 0 0.23602f
C1566 a_4277_n945.t1 0 0.04118f
C1567 a_3133_n1226.t0 0 0.00788f
C1568 a_3133_n1226.t1 0 0.00788f
C1569 a_3589_n1177.n0 0 0.00129f
C1570 a_3589_n1177.t0 0 0
C1571 a_3589_n1177.t1 0 0.00757f
C1572 a_3589_n1177.n1 0 0.01437f
C1573 a_5326_n921.t0 0 0.01249f
C1574 a_5326_n921.t1 0 0.01249f
C1575 a_5523_n945.t0 0 0.03301f
C1576 a_5523_n945.n0 0 0.20326f
C1577 a_5523_n945.t2 0 0.25226f
C1578 a_5523_n945.t1 0 0.04401f
C1579 a_4377_n1226.t0 0 0.00776f
C1580 a_4377_n1226.t1 0 0.00776f
C1581 a_4833_n1177.n0 0 0.00126f
C1582 a_4833_n1177.t0 0 0
C1583 a_4833_n1177.t1 0 0.00739f
C1584 a_4833_n1177.n1 0 0.01402f
C1585 a_6572_n921.t0 0 0.01306f
C1586 a_6572_n921.t1 0 0.01306f
C1587 a_6769_n945.t0 0 0.03431f
C1588 a_6769_n945.n0 0 0.21126f
C1589 a_6769_n945.t2 0 0.26219f
C1590 a_6769_n945.t1 0 0.04574f
C1591 a_5623_n1226.t0 0 0.00819f
C1592 a_5623_n1226.t1 0 0.00819f
C1593 a_6077_n1177.n0 0 0.00127f
C1594 a_6077_n1177.t0 0 0
C1595 a_6077_n1177.t1 0 0.00746f
C1596 a_6077_n1177.n1 0 0.01415f
C1597 a_7818_n921.t0 0 0.013f
C1598 a_7818_n921.t1 0 0.013f
C1599 a_8015_n945.t0 0 0.04599f
C1600 a_8015_n945.n0 0 0.21239f
C1601 a_8015_n945.t1 0 0.2636f
C1602 a_8015_n945.t2 0 0.03449f
C1603 a_6869_n1226.t0 0 0.0081f
C1604 a_6869_n1226.t1 0 0.0081f
C1605 a_7325_n1177.n0 0 0.00126f
C1606 a_7325_n1177.t0 0 0
C1607 a_7325_n1177.t1 0 0.0074f
C1608 a_7325_n1177.n1 0 0.01404f
C1609 a_9064_n921.t0 0 0.01353f
C1610 a_9064_n921.t1 0 0.01353f
C1611 a_9261_n945.t0 0 0.26179f
C1612 a_9261_n945.n0 0 0.21094f
C1613 a_9261_n945.t1 0 0.04567f
C1614 a_9261_n945.t2 0 0.03426f
C1615 a_8115_n1226.t0 0 0.00886f
C1616 a_8115_n1226.t1 0 0.00886f
C1617 a_8571_n1177.n0 0 0.00164f
C1618 a_8571_n1177.t0 0 0
C1619 a_8571_n1177.t1 0 0.0096f
C1620 a_8571_n1177.n1 0 0.01823f
C1621 a_10304_n921.t0 0 0.01285f
C1622 a_10304_n921.t1 0 0.01285f
C1623 a_10501_n945.t0 0 0.04521f
C1624 a_10501_n945.n0 0 0.20877f
C1625 a_10501_n945.t2 0 0.2591f
C1626 a_10501_n945.t1 0 0.0339f
C1627 sky130_fd_sc_hs__nor2b_1_7.B_N.t0 0 0.06108f
C1628 sky130_fd_sc_hs__nor2b_1_7.B_N.n0 0 0.09162f
C1629 sky130_fd_sc_hs__nor2b_1_7.B_N.n1 0 0.04854f
C1630 sky130_fd_sc_hs__nor2b_1_7.B_N.n2 0 0.75884f
C1631 sky130_fd_sc_hs__nor2b_1_7.B_N.t2 0 0.20564f
C1632 sky130_fd_sc_hs__nor2b_1_7.B_N.t4 0 0.05681f
C1633 sky130_fd_sc_hs__nor2b_1_7.B_N.n3 0 0.15987f
C1634 sky130_fd_sc_hs__nor2b_1_7.B_N.t3 0 0.03083f
C1635 sky130_fd_sc_hs__nor2b_1_7.B_N.n4 0 0.47662f
C1636 sky130_fd_sc_hs__nor2b_1_7.B_N.n5 0 0.14671f
C1637 sky130_fd_sc_hs__nor2b_1_7.B_N.t1 0 0.03054f
C1638 a_9361_n1226.t0 0 0.00854f
C1639 a_9361_n1226.t1 0 0.00854f
C1640 a_9809_n1177.n0 0 0.00146f
C1641 a_9809_n1177.t0 0 0
C1642 a_9809_n1177.t1 0 0.0086f
C1643 a_9809_n1177.n1 0 0.01632f
C1644 sky130_fd_sc_hs__and2_1_7.X.t1 0 0.12366f
C1645 sky130_fd_sc_hs__and2_1_7.X.n0 0 1.81554f
C1646 sky130_fd_sc_hs__and2_1_7.X.t3 0 0.0714f
C1647 sky130_fd_sc_hs__and2_1_7.X.n1 0 0.20097f
C1648 sky130_fd_sc_hs__and2_1_7.X.t2 0 0.03875f
C1649 sky130_fd_sc_hs__and2_1_7.X.n2 0 1.7259f
C1650 sky130_fd_sc_hs__and2_1_7.X.n3 0 0.05412f
C1651 sky130_fd_sc_hs__and2_1_7.X.n4 0 0.18301f
C1652 sky130_fd_sc_hs__and2_1_7.X.t0 0 0.06224f
C1653 sky130_fd_sc_hs__and2_1_7.X.n5 0 0.05412f
C1654 sky130_fd_sc_hs__and2_1_7.X.n6 0 0.13297f
C1655 a_11650_n945.t0 0 0.02203f
C1656 a_11650_n945.t1 0 0.02203f
C1657 sky130_fd_sc_hs__nor2b_1_7.Y.t0 0 0.03205f
C1658 sky130_fd_sc_hs__nor2b_1_7.Y.n0 0 0.17541f
C1659 sky130_fd_sc_hs__nor2b_1_7.Y.n1 0 0.05037f
C1660 sky130_fd_sc_hs__nor2b_1_7.Y.n2 0 0.20657f
C1661 sky130_fd_sc_hs__nor2b_1_7.Y.t1 0 0.05371f
C1662 sky130_fd_sc_hs__nor2b_1_7.Y.n3 0 0.04697f
C1663 sky130_fd_sc_hs__nor2b_1_7.Y.n4 0 0.22253f
C1664 sky130_fd_sc_hs__nor2b_1_7.Y.t4 0 0.08222f
C1665 sky130_fd_sc_hs__nor2b_1_7.Y.n5 0 0.22986f
C1666 sky130_fd_sc_hs__nor2b_1_7.Y.t3 0 0.0894f
C1667 sky130_fd_sc_hs__nor2b_1_7.Y.n6 0 0.03472f
C1668 sky130_fd_sc_hs__nor2b_1_7.Y.t2 0 0.04923f
C1669 a_12058_n945.t1 0 0.16165f
C1670 a_12058_n945.t5 0 0.11013f
C1671 a_12058_n945.t3 0 0.18932f
C1672 a_12058_n945.n0 0 0.34978f
C1673 a_12058_n945.n1 0 0.24534f
C1674 a_12058_n945.n2 0 0.50616f
C1675 a_12058_n945.t2 0 0.1487f
C1676 a_12058_n945.t4 0 0.14777f
C1677 a_12058_n945.n3 0 0.76253f
C1678 a_12058_n945.t0 0 0.19615f
C1679 a_12565_n855.t0 0 0.00415f
C1680 a_12565_n855.t5 0 0.07362f
C1681 a_12565_n855.t4 0 0.02633f
C1682 a_12565_n855.n0 0 0.1559f
C1683 a_12565_n855.t1 0 0.0365f
C1684 a_12565_n855.t3 0 0.0901f
C1685 a_12565_n855.n1 0 0.1367f
C1686 a_12565_n855.n2 0 0.28089f
C1687 a_12565_n855.t2 0 0.03155f
C1688 a_12565_n855.n3 0 0.09318f
C1689 a_12413_n850.n0 0 0.01585f
C1690 a_12413_n850.t0 0 0.00528f
C1691 a_12413_n850.n1 0 0.10864f
C1692 a_12413_n850.t1 0 0.02145f
C1693 a_12413_n850.t3 0 0.04771f
C1694 a_12413_n850.n2 0 0.06923f
C1695 a_12413_n850.n3 0 0.48716f
C1696 a_12413_n850.t4 0 0.08384f
C1697 a_12413_n850.t5 0 0.06656f
C1698 a_12413_n850.n4 0 0.25232f
C1699 a_12413_n850.t2 0 0.03178f
C1700 a_12413_n850.n5 0 0.02853f
C1701 a_13062_n999.t1 0 0.107f
C1702 a_13062_n999.t4 0 0.05879f
C1703 a_13062_n999.t2 0 0.04194f
C1704 a_13062_n999.n0 0 0.09156f
C1705 a_13062_n999.n1 0 0.21041f
C1706 a_13062_n999.n2 0 0.16631f
C1707 a_13062_n999.t5 0 0.03598f
C1708 a_13062_n999.t3 0 0.04057f
C1709 a_13062_n999.n3 0 0.25471f
C1710 a_13062_n999.t0 0 0.10233f
C1711 a_13511_n1201.t1 0 0.13324f
C1712 a_13511_n1201.t0 0 0.10094f
C1713 a_13511_n1201.t3 0 0.05644f
C1714 a_13511_n1201.t2 0 0.03865f
C1715 a_13511_n1201.n0 0 0.12236f
C1716 a_13511_n1201.n1 0 0.38462f
C1717 a_13991_n1239.t1 0 0.10806f
C1718 a_13991_n1239.t7 0 0.06896f
C1719 a_13991_n1239.t5 0 0.04104f
C1720 a_13991_n1239.n0 0 0.11236f
C1721 a_13991_n1239.n1 0 0.28553f
C1722 a_13991_n1239.t0 0 0.20714f
C1723 a_13991_n1239.t6 0 0.03596f
C1724 a_13991_n1239.t3 0 0.04482f
C1725 a_13991_n1239.n2 0 0.16682f
C1726 a_13991_n1239.n3 0 0.5589f
C1727 a_13991_n1239.t2 0 0.21108f
C1728 a_13991_n1239.t4 0 0.12284f
C1729 a_13991_n1239.n4 0 0.3821f
C1730 a_12306_n810.t0 0 0.0292f
C1731 a_12306_n810.t3 0 0.03667f
C1732 a_12306_n810.n0 0 0.10884f
C1733 a_12306_n810.t1 0 0.01718f
C1734 a_12306_n810.n1 0 0.23436f
C1735 a_12306_n810.t2 0 0.03056f
C1736 a_12520_n810.t0 0 0.00541f
C1737 a_12520_n810.t1 0 0.00541f
C1738 a_10601_n1226.t0 0 0.00887f
C1739 a_10601_n1226.t1 0 0.00887f
C1740 a_11037_n1177.n0 0 0.00175f
C1741 a_11037_n1177.t0 0 0
C1742 a_11037_n1177.t1 0 0.01027f
C1743 a_11037_n1177.n1 0 0.0195f
C1744 a_12863_n889.t0 0 0.02637f
C1745 a_12863_n889.t2 0 0.03187f
C1746 a_12863_n889.t1 0 0.03501f
C1747 a_12863_n889.t3 0 0.02692f
C1748 a_12863_n889.n0 0 0.07266f
C1749 a_12863_n889.n1 0 0.36825f
C1750 a_12863_n889.t5 0 0.05558f
C1751 a_12863_n889.t4 0 0.03878f
C1752 a_12863_n889.n2 0 0.14682f
C1753 a_12863_n889.n3 0 0.10555f
C1754 a_12970_n805.t0 0 0.01007f
C1755 a_12970_n805.t1 0 0.01007f
C1756 a_13762_n945.t0 0 0.02239f
C1757 a_13762_n945.t1 0 0.02239f
C1758 sky130_fd_sc_hs__dfxtp_1_0.D.t0 0 0.02763f
C1759 sky130_fd_sc_hs__dfxtp_1_0.D.n0 0 0.15123f
C1760 sky130_fd_sc_hs__dfxtp_1_0.D.n1 0 0.04343f
C1761 sky130_fd_sc_hs__dfxtp_1_0.D.n2 0 0.17809f
C1762 sky130_fd_sc_hs__dfxtp_1_0.D.t2 0 0.04631f
C1763 sky130_fd_sc_hs__dfxtp_1_0.D.n3 0 0.02054f
C1764 sky130_fd_sc_hs__dfxtp_1_0.D.n4 0 0.17775f
C1765 sky130_fd_sc_hs__dfxtp_1_0.D.t4 0 0.07164f
C1766 sky130_fd_sc_hs__dfxtp_1_0.D.t3 0 0.07708f
C1767 sky130_fd_sc_hs__dfxtp_1_0.D.n5 0 0.02182f
C1768 sky130_fd_sc_hs__dfxtp_1_0.D.n6 0 0.24447f
C1769 sky130_fd_sc_hs__dfxtp_1_0.D.t1 0 0.04244f
C1770 a_14170_n945.t0 0 0.15154f
C1771 a_14170_n945.t5 0 0.10324f
C1772 a_14170_n945.t3 0 0.17747f
C1773 a_14170_n945.n0 0 0.32789f
C1774 a_14170_n945.n1 0 0.22998f
C1775 a_14170_n945.n2 0 0.47449f
C1776 a_14170_n945.t2 0 0.13939f
C1777 a_14170_n945.t4 0 0.13852f
C1778 a_14170_n945.n3 0 0.71482f
C1779 a_14170_n945.t1 0 0.18388f
C1780 a_14677_n855.t1 0 0.02926f
C1781 a_14677_n855.t5 0 0.06829f
C1782 a_14677_n855.t4 0 0.02442f
C1783 a_14677_n855.n0 0 0.14459f
C1784 a_14677_n855.t0 0 0.03385f
C1785 a_14677_n855.t3 0 0.08357f
C1786 a_14677_n855.n1 0 0.12679f
C1787 a_14677_n855.n2 0 0.26052f
C1788 a_14677_n855.t2 0 0.00385f
C1789 a_14677_n855.n3 0 0.08642f
C1790 a_14525_n850.t0 0 0.01988f
C1791 a_14525_n850.t2 0 0.04423f
C1792 a_14525_n850.t4 0 0.07771f
C1793 a_14525_n850.t5 0 0.0617f
C1794 a_14525_n850.n0 0 0.23389f
C1795 a_14525_n850.t1 0 0.02243f
C1796 a_14525_n850.t3 0 0.02946f
C1797 a_14525_n850.n1 0 0.12431f
C1798 a_14525_n850.n2 0 0.45158f
C1799 a_14525_n850.n3 0 0.06417f
C1800 a_15174_n999.t1 0 0.09127f
C1801 a_15174_n999.t4 0 0.05015f
C1802 a_15174_n999.t2 0 0.03577f
C1803 a_15174_n999.n0 0 0.0781f
C1804 a_15174_n999.n1 0 0.17948f
C1805 a_15174_n999.n2 0 0.14186f
C1806 a_15174_n999.t5 0 0.03069f
C1807 a_15174_n999.t3 0 0.03461f
C1808 a_15174_n999.n3 0 0.21726f
C1809 a_15174_n999.t0 0 0.08728f
C1810 a_14418_n810.n0 0 0.01792f
C1811 a_14418_n810.n1 0 0.05772f
C1812 a_14418_n810.t1 0 0.02656f
C1813 a_14418_n810.t3 0 0.0278f
C1814 a_14418_n810.n2 0 0.21318f
C1815 a_14418_n810.t0 0 0.00745f
C1816 a_14418_n810.t2 0 0.03335f
C1817 a_14418_n810.n3 0 0.03151f
C1818 a_14632_n810.t0 0 0.0046f
C1819 a_14632_n810.t1 0 0.0046f
C1820 a_12583_n1212.t0 0 0.00345f
C1821 a_12583_n1212.t1 0 0.00345f
C1822 a_13020_n1189.t0 0 0.00528f
C1823 a_13020_n1189.t1 0 0.00528f
C1824 a_14975_n889.t1 0 0.02421f
C1825 a_14975_n889.n0 0 0.06533f
C1826 a_14975_n889.t3 0 0.02865f
C1827 a_14975_n889.t2 0 0.02371f
C1828 a_14975_n889.n1 0 0.09491f
C1829 a_14975_n889.n2 0 0.33114f
C1830 a_14975_n889.t5 0 0.04998f
C1831 a_14975_n889.t4 0 0.03487f
C1832 a_14975_n889.n3 0 0.13203f
C1833 a_14975_n889.t0 0 0.03149f
C1834 a_15082_n805.t0 0 0.00842f
C1835 a_15082_n805.t1 0 0.00842f
C1836 a_14695_n1212.t0 0 0.00286f
C1837 a_14695_n1212.t1 0 0.00286f
C1838 a_15132_n1189.t0 0 0.00352f
C1839 a_15132_n1189.t1 0 0.00352f
C1840 VPWR.n0 0 0.01756f
C1841 VPWR.n1 0 0.02082f
C1842 VPWR.n2 0 0.01073f
C1843 VPWR.n3 0 0.01104f
C1844 VPWR.n4 0 0.03181f
C1845 VPWR.t330 0 0.01136f
C1846 VPWR.t250 0 0.01136f
C1847 VPWR.n5 0 0.0247f
C1848 VPWR.n6 0 0.02549f
C1849 VPWR.n7 0 0.02386f
C1850 VPWR.n8 0 0.0104f
C1851 VPWR.n9 0 0.03181f
C1852 VPWR.n10 0 0.00989f
C1853 VPWR.n11 0 0.03181f
C1854 VPWR.n12 0 0.00782f
C1855 VPWR.n13 0 0.03181f
C1856 VPWR.n14 0 0.01121f
C1857 VPWR.n15 0 0.03181f
C1858 VPWR.t214 0 0.00433f
C1859 VPWR.t217 0 0.00795f
C1860 VPWR.n16 0 0.03818f
C1861 VPWR.n17 0 0.01499f
C1862 VPWR.n18 0 0.01004f
C1863 VPWR.n19 0 0.03181f
C1864 VPWR.t200 0 0.03321f
C1865 VPWR.n20 0 0.02038f
C1866 VPWR.t52 0 0.01136f
C1867 VPWR.t236 0 0.01136f
C1868 VPWR.n21 0 0.0247f
C1869 VPWR.n22 0 0.01104f
C1870 VPWR.n23 0 0.03181f
C1871 VPWR.n24 0 0.00787f
C1872 VPWR.t44 0 0.01263f
C1873 VPWR.t225 0 0.00852f
C1874 VPWR.n25 0 0.03332f
C1875 VPWR.n26 0 0.06494f
C1876 VPWR.n27 0 0.03181f
C1877 VPWR.n28 0 0.01104f
C1878 VPWR.n29 0 0.03181f
C1879 VPWR.t302 0 0.00433f
C1880 VPWR.t82 0 0.00795f
C1881 VPWR.n30 0 0.03818f
C1882 VPWR.n31 0 0.01499f
C1883 VPWR.n32 0 0.03181f
C1884 VPWR.n33 0 0.01004f
C1885 VPWR.n34 0 0.03181f
C1886 VPWR.t86 0 0.03321f
C1887 VPWR.n35 0 0.02038f
C1888 VPWR.t294 0 0.01136f
C1889 VPWR.t246 0 0.01136f
C1890 VPWR.n36 0 0.0247f
C1891 VPWR.n37 0 0.01104f
C1892 VPWR.n38 0 0.03181f
C1893 VPWR.n39 0 0.00787f
C1894 VPWR.t283 0 0.01263f
C1895 VPWR.t96 0 0.00852f
C1896 VPWR.n40 0 0.03332f
C1897 VPWR.n41 0 0.06494f
C1898 VPWR.n42 0 0.03181f
C1899 VPWR.n43 0 0.01104f
C1900 VPWR.n44 0 0.03181f
C1901 VPWR.t101 0 0.00433f
C1902 VPWR.t149 0 0.00795f
C1903 VPWR.n45 0 0.03818f
C1904 VPWR.n46 0 0.01499f
C1905 VPWR.n47 0 0.03181f
C1906 VPWR.n48 0 0.01004f
C1907 VPWR.n49 0 0.03181f
C1908 VPWR.t146 0 0.03321f
C1909 VPWR.n50 0 0.02038f
C1910 VPWR.t28 0 0.01136f
C1911 VPWR.t244 0 0.01136f
C1912 VPWR.n51 0 0.0247f
C1913 VPWR.n52 0 0.01104f
C1914 VPWR.n53 0 0.03181f
C1915 VPWR.n54 0 0.00787f
C1916 VPWR.t203 0 0.01263f
C1917 VPWR.t171 0 0.00852f
C1918 VPWR.n55 0 0.03332f
C1919 VPWR.n56 0 0.06494f
C1920 VPWR.n57 0 0.03181f
C1921 VPWR.n58 0 0.01104f
C1922 VPWR.n59 0 0.03181f
C1923 VPWR.t320 0 0.00433f
C1924 VPWR.t308 0 0.00795f
C1925 VPWR.n60 0 0.03818f
C1926 VPWR.n61 0 0.01499f
C1927 VPWR.n62 0 0.03181f
C1928 VPWR.n63 0 0.01004f
C1929 VPWR.n64 0 0.03181f
C1930 VPWR.t120 0 0.03321f
C1931 VPWR.n65 0 0.02038f
C1932 VPWR.t306 0 0.01136f
C1933 VPWR.t238 0 0.01136f
C1934 VPWR.n66 0 0.0247f
C1935 VPWR.n67 0 0.01104f
C1936 VPWR.n68 0 0.03181f
C1937 VPWR.n69 0 0.00787f
C1938 VPWR.t7 0 0.01263f
C1939 VPWR.t323 0 0.00852f
C1940 VPWR.n70 0 0.03332f
C1941 VPWR.n71 0 0.06494f
C1942 VPWR.n72 0 0.03181f
C1943 VPWR.n73 0 0.01104f
C1944 VPWR.n74 0 0.03181f
C1945 VPWR.t62 0 0.00433f
C1946 VPWR.t158 0 0.00795f
C1947 VPWR.n75 0 0.03818f
C1948 VPWR.n76 0 0.01499f
C1949 VPWR.n77 0 0.03181f
C1950 VPWR.n78 0 0.01004f
C1951 VPWR.n79 0 0.03181f
C1952 VPWR.t89 0 0.03321f
C1953 VPWR.n80 0 0.02038f
C1954 VPWR.t38 0 0.01136f
C1955 VPWR.t242 0 0.01136f
C1956 VPWR.n81 0 0.0247f
C1957 VPWR.n82 0 0.01104f
C1958 VPWR.n83 0 0.03181f
C1959 VPWR.n84 0 0.00787f
C1960 VPWR.t168 0 0.01263f
C1961 VPWR.t196 0 0.00852f
C1962 VPWR.n85 0 0.03332f
C1963 VPWR.n86 0 0.06494f
C1964 VPWR.n87 0 0.03181f
C1965 VPWR.n88 0 0.01104f
C1966 VPWR.n89 0 0.02154f
C1967 VPWR.t161 0 0.00433f
C1968 VPWR.t292 0 0.00795f
C1969 VPWR.n90 0 0.03818f
C1970 VPWR.n91 0 0.01499f
C1971 VPWR.n92 0 0.16156f
C1972 VPWR.n93 0 0.13503f
C1973 VPWR.n94 0 0.01104f
C1974 VPWR.n95 0 0.12197f
C1975 VPWR.n96 0 0.03181f
C1976 VPWR.t304 0 0.01136f
C1977 VPWR.t240 0 0.01136f
C1978 VPWR.n97 0 0.0247f
C1979 VPWR.n98 0 0.02549f
C1980 VPWR.n99 0 0.02386f
C1981 VPWR.n100 0 0.0104f
C1982 VPWR.n101 0 0.03181f
C1983 VPWR.n102 0 0.03712f
C1984 VPWR.t18 0 0.01263f
C1985 VPWR.t175 0 0.00852f
C1986 VPWR.n103 0 0.03332f
C1987 VPWR.n104 0 0.03181f
C1988 VPWR.t187 0 0.01623f
C1989 VPWR.n105 0 0.01104f
C1990 VPWR.n106 0 0.02104f
C1991 VPWR.n107 0 0.17768f
C1992 VPWR.n108 0 0.01104f
C1993 VPWR.n109 0 0.02154f
C1994 VPWR.n110 0 0.03181f
C1995 VPWR.n111 0 0.03181f
C1996 VPWR.n112 0 0.00782f
C1997 VPWR.n113 0 0.04771f
C1998 VPWR.n114 0 0.00782f
C1999 VPWR.n115 0 0.06736f
C2000 VPWR.n116 0 0.04967f
C2001 VPWR.n117 0 0.27619f
C2002 VPWR.t17 0 0.26464f
C2003 VPWR.t174 0 0.19054f
C2004 VPWR.t186 0 0.20563f
C2005 VPWR.t113 0 0.14589f
C2006 VPWR.t26 0 0.15595f
C2007 VPWR.t297 0 0.16664f
C2008 VPWR.t287 0 0.12703f
C2009 VPWR.t215 0 0.11633f
C2010 VPWR.t107 0 0.13457f
C2011 VPWR.t97 0 0.22324f
C2012 VPWR.t329 0 0.21255f
C2013 VPWR.t249 0 0.12011f
C2014 VPWR.t324 0 0.13646f
C2015 VPWR.t269 0 0.12954f
C2016 VPWR.t227 0 0.16538f
C2017 VPWR.t55 0 0.12703f
C2018 VPWR.t177 0 0.19054f
C2019 VPWR.t133 0 0.20563f
C2020 VPWR.t118 0 0.14589f
C2021 VPWR.t16 0 0.15595f
C2022 VPWR.t213 0 0.16664f
C2023 VPWR.t216 0 0.12703f
C2024 VPWR.t185 0 0.11633f
C2025 VPWR.t201 0 0.13457f
C2026 VPWR.t199 0 0.22324f
C2027 VPWR.t51 0 0.21255f
C2028 VPWR.t235 0 0.12011f
C2029 VPWR.t90 0 0.13646f
C2030 VPWR.t257 0 0.12954f
C2031 VPWR.t45 0 0.16538f
C2032 VPWR.t43 0 0.12703f
C2033 VPWR.t224 0 0.19054f
C2034 VPWR.t135 0 0.20563f
C2035 VPWR.t318 0 0.14589f
C2036 VPWR.t68 0 0.15595f
C2037 VPWR.t301 0 0.16664f
C2038 VPWR.t81 0 0.12703f
C2039 VPWR.t280 0 0.11633f
C2040 VPWR.t104 0 0.13457f
C2041 VPWR.t85 0 0.22324f
C2042 VPWR.t293 0 0.21255f
C2043 VPWR.t245 0 0.12011f
C2044 VPWR.t281 0 0.13646f
C2045 VPWR.t261 0 0.12954f
C2046 VPWR.t65 0 0.16538f
C2047 VPWR.t282 0 0.12703f
C2048 VPWR.t95 0 0.19054f
C2049 VPWR.t222 0 0.20563f
C2050 VPWR.t176 0 0.14589f
C2051 VPWR.t179 0 0.15595f
C2052 VPWR.t100 0 0.16664f
C2053 VPWR.t148 0 0.12703f
C2054 VPWR.t204 0 0.11633f
C2055 VPWR.t206 0 0.13457f
C2056 VPWR.t145 0 0.22324f
C2057 VPWR.t27 0 0.21255f
C2058 VPWR.t243 0 0.12011f
C2059 VPWR.t87 0 0.13646f
C2060 VPWR.t267 0 0.12954f
C2061 VPWR.t271 0 0.16538f
C2062 VPWR.t202 0 0.12703f
C2063 VPWR.t170 0 0.19054f
C2064 VPWR.t209 0 0.20563f
C2065 VPWR.t286 0 0.14589f
C2066 VPWR.t99 0 0.15595f
C2067 VPWR.t319 0 0.16664f
C2068 VPWR.t307 0 0.12703f
C2069 VPWR.t273 0 0.11633f
C2070 VPWR.t181 0 0.13457f
C2071 VPWR.t119 0 0.22324f
C2072 VPWR.t305 0 0.21255f
C2073 VPWR.t237 0 0.12011f
C2074 VPWR.t184 0 0.13646f
C2075 VPWR.t263 0 0.12954f
C2076 VPWR.t220 0 0.16538f
C2077 VPWR.t6 0 0.12703f
C2078 VPWR.t322 0 0.19054f
C2079 VPWR.t284 0 0.20563f
C2080 VPWR.t162 0 0.14589f
C2081 VPWR.t121 0 0.15595f
C2082 VPWR.t61 0 0.16664f
C2083 VPWR.t157 0 0.12703f
C2084 VPWR.t14 0 0.11633f
C2085 VPWR.t147 0 0.13457f
C2086 VPWR.t88 0 0.22324f
C2087 VPWR.t37 0 0.21255f
C2088 VPWR.t241 0 0.12011f
C2089 VPWR.t128 0 0.13646f
C2090 VPWR.t253 0 0.12954f
C2091 VPWR.t116 0 0.16538f
C2092 VPWR.t167 0 0.12703f
C2093 VPWR.t195 0 0.19054f
C2094 VPWR.t57 0 0.20563f
C2095 VPWR.t169 0 0.14589f
C2096 VPWR.t143 0 0.15595f
C2097 VPWR.t160 0 0.16664f
C2098 VPWR.t291 0 0.12703f
C2099 VPWR.t144 0 0.11633f
C2100 VPWR.t42 0 0.13457f
C2101 VPWR.t24 0 0.22324f
C2102 VPWR.t303 0 0.21255f
C2103 VPWR.t239 0 0.12011f
C2104 VPWR.t321 0 0.13646f
C2105 VPWR.t255 0 0.12954f
C2106 VPWR.t312 0 0.16538f
C2107 VPWR.n118 0 0.10911f
C2108 VPWR.n119 0 0.01557f
C2109 VPWR.n120 0 0.02386f
C2110 VPWR.n121 0 0.0092f
C2111 VPWR.n122 0 0.00787f
C2112 VPWR.t313 0 0.01761f
C2113 VPWR.t256 0 0.00293f
C2114 VPWR.n123 0 0.04689f
C2115 VPWR.n124 0 0.0637f
C2116 VPWR.n125 0 0.03181f
C2117 VPWR.n126 0 0.03181f
C2118 VPWR.n127 0 0.02386f
C2119 VPWR.n128 0 0.01104f
C2120 VPWR.n129 0 0.01104f
C2121 VPWR.n130 0 0.00563f
C2122 VPWR.n131 0 0.03181f
C2123 VPWR.n132 0 0.03181f
C2124 VPWR.n133 0 0.01043f
C2125 VPWR.n134 0 0.01181f
C2126 VPWR.t25 0 0.03321f
C2127 VPWR.n135 0 0.02038f
C2128 VPWR.n136 0 0.01004f
C2129 VPWR.n137 0 0.03181f
C2130 VPWR.n138 0 0.03181f
C2131 VPWR.n139 0 0.01988f
C2132 VPWR.n140 0 0.01104f
C2133 VPWR.n141 0 0.00956f
C2134 VPWR.n142 0 0.00967f
C2135 VPWR.n143 0 0.00967f
C2136 VPWR.n144 0 0.06773f
C2137 VPWR.n145 0 0.01058f
C2138 VPWR.n146 0 0.00592f
C2139 VPWR.t232 0 0.03146f
C2140 VPWR.n147 0 0.05978f
C2141 VPWR.n148 0 0.0104f
C2142 VPWR.n149 0 0.03181f
C2143 VPWR.n150 0 0.01104f
C2144 VPWR.n151 0 0.02386f
C2145 VPWR.n152 0 0.00816f
C2146 VPWR.n153 0 0.03181f
C2147 VPWR.t151 0 0.01263f
C2148 VPWR.t60 0 0.00852f
C2149 VPWR.n154 0 0.03332f
C2150 VPWR.n155 0 0.03181f
C2151 VPWR.t290 0 0.01623f
C2152 VPWR.n156 0 0.01104f
C2153 VPWR.n157 0 0.03181f
C2154 VPWR.t155 0 0.00433f
C2155 VPWR.t336 0 0.00795f
C2156 VPWR.n158 0 0.03818f
C2157 VPWR.n159 0 0.01499f
C2158 VPWR.n160 0 0.03181f
C2159 VPWR.n161 0 0.01004f
C2160 VPWR.n162 0 0.03181f
C2161 VPWR.t296 0 0.03321f
C2162 VPWR.n163 0 0.02038f
C2163 VPWR.t326 0 0.01136f
C2164 VPWR.t252 0 0.01136f
C2165 VPWR.n164 0 0.0247f
C2166 VPWR.n165 0 0.01104f
C2167 VPWR.n166 0 0.03181f
C2168 VPWR.n167 0 0.03181f
C2169 VPWR.t132 0 0.01761f
C2170 VPWR.t260 0 0.00293f
C2171 VPWR.n168 0 0.04689f
C2172 VPWR.n169 0 0.01104f
C2173 VPWR.n170 0 0.03181f
C2174 VPWR.t76 0 0.01263f
C2175 VPWR.t334 0 0.00852f
C2176 VPWR.n171 0 0.03332f
C2177 VPWR.t72 0 0.01623f
C2178 VPWR.n172 0 0.04771f
C2179 VPWR.n173 0 0.03181f
C2180 VPWR.n174 0 0.01073f
C2181 VPWR.n175 0 0.03181f
C2182 VPWR.n176 0 0.01104f
C2183 VPWR.n177 0 0.03181f
C2184 VPWR.t70 0 0.01136f
C2185 VPWR.t248 0 0.01136f
C2186 VPWR.n178 0 0.0247f
C2187 VPWR.n179 0 0.02549f
C2188 VPWR.n180 0 0.02386f
C2189 VPWR.n181 0 0.0104f
C2190 VPWR.n182 0 0.03181f
C2191 VPWR.t78 0 0.01761f
C2192 VPWR.t266 0 0.00293f
C2193 VPWR.n183 0 0.04689f
C2194 VPWR.n184 0 0.01046f
C2195 VPWR.n185 0 0.03181f
C2196 VPWR.t4 0 0.00533f
C2197 VPWR.t36 0 0.01335f
C2198 VPWR.n186 0 0.03807f
C2199 VPWR.t30 0 0.03146f
C2200 VPWR.n187 0 0.05978f
C2201 VPWR.n188 0 0.0104f
C2202 VPWR.n189 0 0.03181f
C2203 VPWR.t54 0 0.01552f
C2204 VPWR.t311 0 0.01628f
C2205 VPWR.n190 0 0.03243f
C2206 VPWR.n191 0 0.01104f
C2207 VPWR.n192 0 0.02386f
C2208 VPWR.t13 0 0.04179f
C2209 VPWR.t164 0 0.00533f
C2210 VPWR.t141 0 0.01335f
C2211 VPWR.n193 0 0.03807f
C2212 VPWR.n194 0 0.05894f
C2213 VPWR.n195 0 0.03181f
C2214 VPWR.t50 0 0.03146f
C2215 VPWR.n196 0 0.01058f
C2216 VPWR.n197 0 0.03181f
C2217 VPWR.t127 0 0.01552f
C2218 VPWR.t106 0 0.01628f
C2219 VPWR.n198 0 0.03243f
C2220 VPWR.n199 0 0.01104f
C2221 VPWR.n200 0 0.03181f
C2222 VPWR.t192 0 0.04179f
C2223 VPWR.n201 0 0.01046f
C2224 VPWR.n202 0 0.03181f
C2225 VPWR.t94 0 0.00533f
C2226 VPWR.t183 0 0.01335f
C2227 VPWR.n203 0 0.03807f
C2228 VPWR.t80 0 0.03146f
C2229 VPWR.n204 0 0.05978f
C2230 VPWR.n205 0 0.0104f
C2231 VPWR.n206 0 0.03181f
C2232 VPWR.t64 0 0.01552f
C2233 VPWR.t300 0 0.01628f
C2234 VPWR.n207 0 0.03243f
C2235 VPWR.n208 0 0.01104f
C2236 VPWR.n209 0 0.02386f
C2237 VPWR.t109 0 0.04179f
C2238 VPWR.t23 0 0.00533f
C2239 VPWR.t48 0 0.01335f
C2240 VPWR.n210 0 0.03807f
C2241 VPWR.n211 0 0.05894f
C2242 VPWR.n212 0 0.03181f
C2243 VPWR.t123 0 0.03146f
C2244 VPWR.n213 0 0.01104f
C2245 VPWR.n214 0 0.03181f
C2246 VPWR.t32 0 0.01552f
C2247 VPWR.t277 0 0.01628f
C2248 VPWR.n215 0 0.03243f
C2249 VPWR.n216 0 0.01104f
C2250 VPWR.n217 0 0.03181f
C2251 VPWR.t9 0 0.04179f
C2252 VPWR.n218 0 0.01058f
C2253 VPWR.n219 0 0.03181f
C2254 VPWR.t92 0 0.00533f
C2255 VPWR.t173 0 0.01335f
C2256 VPWR.n220 0 0.03807f
C2257 VPWR.t166 0 0.03146f
C2258 VPWR.n221 0 0.05978f
C2259 VPWR.n222 0 0.0104f
C2260 VPWR.n223 0 0.03181f
C2261 VPWR.t190 0 0.01552f
C2262 VPWR.t275 0 0.01628f
C2263 VPWR.n224 0 0.03243f
C2264 VPWR.n225 0 0.01104f
C2265 VPWR.n226 0 0.02386f
C2266 VPWR.t84 0 0.04179f
C2267 VPWR.t115 0 0.00533f
C2268 VPWR.t208 0 0.01335f
C2269 VPWR.n227 0 0.03807f
C2270 VPWR.n228 0 0.05894f
C2271 VPWR.n229 0 0.03181f
C2272 VPWR.t315 0 0.03146f
C2273 VPWR.n230 0 0.01104f
C2274 VPWR.n231 0 0.03181f
C2275 VPWR.t125 0 0.01552f
C2276 VPWR.t332 0 0.01628f
C2277 VPWR.n232 0 0.03243f
C2278 VPWR.n233 0 0.01104f
C2279 VPWR.n234 0 0.03181f
C2280 VPWR.t40 0 0.04179f
C2281 VPWR.n235 0 0.01035f
C2282 VPWR.n236 0 0.03181f
C2283 VPWR.t20 0 0.00533f
C2284 VPWR.t34 0 0.01335f
C2285 VPWR.n237 0 0.03807f
C2286 VPWR.t2 0 0.03146f
C2287 VPWR.n238 0 0.05978f
C2288 VPWR.n239 0 0.0104f
C2289 VPWR.n240 0 0.03181f
C2290 VPWR.t279 0 0.01552f
C2291 VPWR.t317 0 0.01628f
C2292 VPWR.n241 0 0.03243f
C2293 VPWR.n242 0 0.01104f
C2294 VPWR.n243 0 0.02521f
C2295 VPWR.t153 0 0.04179f
C2296 VPWR.n244 0 0.08782f
C2297 VPWR.n245 0 0.00947f
C2298 VPWR.n246 0 0.00649f
C2299 VPWR.n247 0 0.06565f
C2300 VPWR.n248 0 0.00626f
C2301 VPWR.n249 0 0.03048f
C2302 VPWR.n250 0 0.03181f
C2303 VPWR.n251 0 0.03181f
C2304 VPWR.n252 0 0.01104f
C2305 VPWR.n253 0 0.00661f
C2306 VPWR.n254 0 0.05087f
C2307 VPWR.n255 0 0.03181f
C2308 VPWR.n256 0 0.03181f
C2309 VPWR.n257 0 0.02386f
C2310 VPWR.n258 0 0.01104f
C2311 VPWR.n259 0 0.00678f
C2312 VPWR.n260 0 0.02386f
C2313 VPWR.n261 0 0.03181f
C2314 VPWR.n262 0 0.00592f
C2315 VPWR.n263 0 0.0077f
C2316 VPWR.n264 0 0.05894f
C2317 VPWR.n265 0 0.03181f
C2318 VPWR.n266 0 0.02319f
C2319 VPWR.n267 0 0.02386f
C2320 VPWR.n268 0 0.00626f
C2321 VPWR.n269 0 0.06565f
C2322 VPWR.n270 0 0.00626f
C2323 VPWR.n271 0 0.01104f
C2324 VPWR.n272 0 0.03181f
C2325 VPWR.n273 0 0.03181f
C2326 VPWR.n274 0 0.03181f
C2327 VPWR.n275 0 0.00661f
C2328 VPWR.n276 0 0.05087f
C2329 VPWR.n277 0 0.0104f
C2330 VPWR.n278 0 0.03181f
C2331 VPWR.n279 0 0.02386f
C2332 VPWR.n280 0 0.02386f
C2333 VPWR.n281 0 0.00678f
C2334 VPWR.n282 0 0.05978f
C2335 VPWR.n283 0 0.00592f
C2336 VPWR.n284 0 0.0077f
C2337 VPWR.n285 0 0.03181f
C2338 VPWR.n286 0 0.03181f
C2339 VPWR.n287 0 0.02352f
C2340 VPWR.n288 0 0.01046f
C2341 VPWR.n289 0 0.00638f
C2342 VPWR.n290 0 0.06565f
C2343 VPWR.n291 0 0.00626f
C2344 VPWR.n292 0 0.03181f
C2345 VPWR.n293 0 0.03181f
C2346 VPWR.n294 0 0.03181f
C2347 VPWR.n295 0 0.01104f
C2348 VPWR.n296 0 0.00661f
C2349 VPWR.n297 0 0.05087f
C2350 VPWR.n298 0 0.03181f
C2351 VPWR.n299 0 0.03181f
C2352 VPWR.n300 0 0.02352f
C2353 VPWR.n301 0 0.01092f
C2354 VPWR.n302 0 0.00667f
C2355 VPWR.n303 0 0.02386f
C2356 VPWR.n304 0 0.03181f
C2357 VPWR.n305 0 0.00592f
C2358 VPWR.n306 0 0.0077f
C2359 VPWR.n307 0 0.05894f
C2360 VPWR.n308 0 0.03181f
C2361 VPWR.n309 0 0.02386f
C2362 VPWR.n310 0 0.02386f
C2363 VPWR.n311 0 0.00649f
C2364 VPWR.n312 0 0.06565f
C2365 VPWR.n313 0 0.00626f
C2366 VPWR.n314 0 0.01104f
C2367 VPWR.n315 0 0.03181f
C2368 VPWR.n316 0 0.03181f
C2369 VPWR.n317 0 0.03181f
C2370 VPWR.n318 0 0.00661f
C2371 VPWR.n319 0 0.05087f
C2372 VPWR.n320 0 0.0104f
C2373 VPWR.n321 0 0.03181f
C2374 VPWR.n322 0 0.02386f
C2375 VPWR.n323 0 0.02386f
C2376 VPWR.n324 0 0.00678f
C2377 VPWR.n325 0 0.05978f
C2378 VPWR.n326 0 0.00592f
C2379 VPWR.n327 0 0.0077f
C2380 VPWR.n328 0 0.03181f
C2381 VPWR.n329 0 0.03181f
C2382 VPWR.n330 0 0.02352f
C2383 VPWR.n331 0 0.01046f
C2384 VPWR.n332 0 0.00638f
C2385 VPWR.n333 0 0.06565f
C2386 VPWR.n334 0 0.00626f
C2387 VPWR.n335 0 0.03181f
C2388 VPWR.n336 0 0.03181f
C2389 VPWR.n337 0 0.03181f
C2390 VPWR.n338 0 0.01104f
C2391 VPWR.n339 0 0.00661f
C2392 VPWR.n340 0 0.05087f
C2393 VPWR.n341 0 0.03181f
C2394 VPWR.n342 0 0.03181f
C2395 VPWR.n343 0 0.02386f
C2396 VPWR.n344 0 0.01104f
C2397 VPWR.n345 0 0.00678f
C2398 VPWR.n346 0 0.02386f
C2399 VPWR.n347 0 0.03181f
C2400 VPWR.n348 0 0.00592f
C2401 VPWR.n349 0 0.0077f
C2402 VPWR.n350 0 0.05894f
C2403 VPWR.n351 0 0.03181f
C2404 VPWR.n352 0 0.02352f
C2405 VPWR.n353 0 0.02386f
C2406 VPWR.n354 0 0.00638f
C2407 VPWR.n355 0 0.06565f
C2408 VPWR.n356 0 0.00626f
C2409 VPWR.n357 0 0.01104f
C2410 VPWR.n358 0 0.03181f
C2411 VPWR.n359 0 0.03181f
C2412 VPWR.n360 0 0.03181f
C2413 VPWR.n361 0 0.00661f
C2414 VPWR.n362 0 0.05087f
C2415 VPWR.n363 0 0.0104f
C2416 VPWR.n364 0 0.03181f
C2417 VPWR.n365 0 0.02253f
C2418 VPWR.n366 0 0.02386f
C2419 VPWR.n367 0 0.00632f
C2420 VPWR.n368 0 0.05978f
C2421 VPWR.n369 0 0.00592f
C2422 VPWR.n370 0 0.0077f
C2423 VPWR.n371 0 0.03181f
C2424 VPWR.n372 0 0.03181f
C2425 VPWR.n373 0 0.02386f
C2426 VPWR.n374 0 0.01058f
C2427 VPWR.n375 0 0.00649f
C2428 VPWR.n376 0 0.06565f
C2429 VPWR.n377 0 0.00626f
C2430 VPWR.n378 0 0.03181f
C2431 VPWR.n379 0 0.03181f
C2432 VPWR.n380 0 0.03181f
C2433 VPWR.n381 0 0.01104f
C2434 VPWR.n382 0 0.00661f
C2435 VPWR.n383 0 0.05087f
C2436 VPWR.n384 0 0.03181f
C2437 VPWR.n385 0 0.03181f
C2438 VPWR.n386 0 0.02054f
C2439 VPWR.n387 0 0.00989f
C2440 VPWR.n388 0 0.00563f
C2441 VPWR.n389 0 0.02386f
C2442 VPWR.n390 0 0.03181f
C2443 VPWR.n391 0 0.00592f
C2444 VPWR.n392 0 0.0077f
C2445 VPWR.n393 0 0.05894f
C2446 VPWR.n394 0 0.03181f
C2447 VPWR.n395 0 0.02352f
C2448 VPWR.n396 0 0.02386f
C2449 VPWR.n397 0 0.01092f
C2450 VPWR.n398 0 0.00787f
C2451 VPWR.n399 0 0.0637f
C2452 VPWR.n400 0 0.03181f
C2453 VPWR.n401 0 0.03181f
C2454 VPWR.n402 0 0.02386f
C2455 VPWR.n403 0 0.01104f
C2456 VPWR.n404 0 0.01104f
C2457 VPWR.n405 0 0.00563f
C2458 VPWR.n406 0 0.03181f
C2459 VPWR.n407 0 0.03181f
C2460 VPWR.n408 0 0.01043f
C2461 VPWR.n409 0 0.01181f
C2462 VPWR.t103 0 0.03321f
C2463 VPWR.n410 0 0.02038f
C2464 VPWR.n411 0 0.01004f
C2465 VPWR.n412 0 0.03181f
C2466 VPWR.n413 0 0.03181f
C2467 VPWR.n414 0 0.03181f
C2468 VPWR.n415 0 0.01104f
C2469 VPWR.n416 0 0.00956f
C2470 VPWR.t212 0 0.00433f
C2471 VPWR.t130 0 0.00795f
C2472 VPWR.n417 0 0.03818f
C2473 VPWR.n418 0 0.01499f
C2474 VPWR.n419 0 0.01121f
C2475 VPWR.n420 0 0.03181f
C2476 VPWR.n421 0 0.03181f
C2477 VPWR.n422 0 0.03181f
C2478 VPWR.n423 0 0.01104f
C2479 VPWR.n424 0 0.01104f
C2480 VPWR.n425 0 0.00782f
C2481 VPWR.n426 0 0.03181f
C2482 VPWR.n427 0 0.03181f
C2483 VPWR.n428 0 0.03181f
C2484 VPWR.n429 0 0.00782f
C2485 VPWR.n430 0 0.06494f
C2486 VPWR.n431 0 0.00989f
C2487 VPWR.n432 0 0.02386f
C2488 VPWR.n433 0 0.02386f
C2489 VPWR.n434 0 0.03181f
C2490 VPWR.n435 0 0.00787f
C2491 VPWR.n436 0 0.0637f
C2492 VPWR.n437 0 0.0104f
C2493 VPWR.n438 0 0.01104f
C2494 VPWR.n439 0 0.02386f
C2495 VPWR.n440 0 0.02386f
C2496 VPWR.n441 0 0.03181f
C2497 VPWR.n442 0 0.00563f
C2498 VPWR.n443 0 0.02549f
C2499 VPWR.n444 0 0.01043f
C2500 VPWR.n445 0 0.01181f
C2501 VPWR.n446 0 0.03181f
C2502 VPWR.n447 0 0.03181f
C2503 VPWR.n448 0 0.03181f
C2504 VPWR.n449 0 0.01104f
C2505 VPWR.n450 0 0.01104f
C2506 VPWR.n451 0 0.00956f
C2507 VPWR.n452 0 0.03181f
C2508 VPWR.n453 0 0.03181f
C2509 VPWR.n454 0 0.01121f
C2510 VPWR.n455 0 0.01073f
C2511 VPWR.n456 0 0.01104f
C2512 VPWR.n457 0 0.03181f
C2513 VPWR.n458 0 0.03181f
C2514 VPWR.n459 0 0.03181f
C2515 VPWR.n460 0 0.00782f
C2516 VPWR.n461 0 0.04771f
C2517 VPWR.n462 0 0.00782f
C2518 VPWR.n463 0 0.06494f
C2519 VPWR.n464 0 0.03181f
C2520 VPWR.n465 0 0.02386f
C2521 VPWR.n466 0 0.1945f
C2522 VPWR.t150 0 0.23485f
C2523 VPWR.t59 0 0.19054f
C2524 VPWR.t289 0 0.20563f
C2525 VPWR.t197 0 0.14589f
C2526 VPWR.t198 0 0.15595f
C2527 VPWR.t154 0 0.16664f
C2528 VPWR.t335 0 0.12703f
C2529 VPWR.t188 0 0.11633f
C2530 VPWR.t74 0 0.13457f
C2531 VPWR.t295 0 0.22324f
C2532 VPWR.t325 0 0.21255f
C2533 VPWR.t251 0 0.12011f
C2534 VPWR.t328 0 0.13646f
C2535 VPWR.t259 0 0.12954f
C2536 VPWR.t131 0 0.16538f
C2537 VPWR.t75 0 0.12703f
C2538 VPWR.t333 0 0.19054f
C2539 VPWR.t71 0 0.20563f
C2540 VPWR.t5 0 0.14589f
C2541 VPWR.t180 0 0.15595f
C2542 VPWR.t211 0 0.16664f
C2543 VPWR.t129 0 0.12703f
C2544 VPWR.t112 0 0.11633f
C2545 VPWR.t21 0 0.13457f
C2546 VPWR.t102 0 0.22324f
C2547 VPWR.t69 0 0.21255f
C2548 VPWR.t247 0 0.12011f
C2549 VPWR.t226 0 0.13646f
C2550 VPWR.t265 0 0.12954f
C2551 VPWR.t77 0 0.16538f
C2552 VPWR.t3 0 0.144f
C2553 VPWR.t35 0 0.13017f
C2554 VPWR.t29 0 0.15658f
C2555 VPWR.t139 0 0.12388f
C2556 VPWR.t53 0 0.13457f
C2557 VPWR.t310 0 0.20374f
C2558 VPWR.t15 0 0.18488f
C2559 VPWR.t12 0 0.14275f
C2560 VPWR.t163 0 0.14526f
C2561 VPWR.t140 0 0.13017f
C2562 VPWR.t49 0 0.15658f
C2563 VPWR.t205 0 0.13143f
C2564 VPWR.t126 0 0.13457f
C2565 VPWR.t105 0 0.20374f
C2566 VPWR.t111 0 0.18488f
C2567 VPWR.t191 0 0.14275f
C2568 VPWR.t93 0 0.144f
C2569 VPWR.t182 0 0.13017f
C2570 VPWR.t79 0 0.15658f
C2571 VPWR.t327 0 0.13646f
C2572 VPWR.t63 0 0.13457f
C2573 VPWR.t299 0 0.20374f
C2574 VPWR.t156 0 0.18488f
C2575 VPWR.t108 0 0.14275f
C2576 VPWR.t22 0 0.144f
C2577 VPWR.t47 0 0.13017f
C2578 VPWR.t122 0 0.15658f
C2579 VPWR.t0 0 0.13646f
C2580 VPWR.t31 0 0.13457f
C2581 VPWR.t276 0 0.20374f
C2582 VPWR.t193 0 0.18488f
C2583 VPWR.t8 0 0.14275f
C2584 VPWR.t91 0 0.14526f
C2585 VPWR.t172 0 0.13017f
C2586 VPWR.t165 0 0.15658f
C2587 VPWR.t73 0 0.1352f
C2588 VPWR.t189 0 0.13457f
C2589 VPWR.t274 0 0.20374f
C2590 VPWR.t309 0 0.18488f
C2591 VPWR.t83 0 0.14275f
C2592 VPWR.t114 0 0.144f
C2593 VPWR.t207 0 0.13017f
C2594 VPWR.t314 0 0.15658f
C2595 VPWR.t41 0 0.13646f
C2596 VPWR.t124 0 0.13457f
C2597 VPWR.t331 0 0.20374f
C2598 VPWR.t67 0 0.18488f
C2599 VPWR.t39 0 0.14275f
C2600 VPWR.t19 0 0.14275f
C2601 VPWR.t33 0 0.13017f
C2602 VPWR.t1 0 0.15658f
C2603 VPWR.t110 0 0.13646f
C2604 VPWR.t278 0 0.13457f
C2605 VPWR.t316 0 0.20374f
C2606 VPWR.t142 0 0.18488f
C2607 VPWR.t152 0 0.14275f
C2608 VPWR.t10 0 0.14526f
C2609 VPWR.t218 0 0.13017f
C2610 VPWR.t231 0 0.15658f
C2611 VPWR.t194 0 0.1352f
C2612 VPWR.t137 0 0.13457f
C2613 VPWR.t233 0 0.20374f
C2614 VPWR.t159 0 0.18488f
C2615 VPWR.t229 0 0.14275f
C2616 VPWR.n467 0 0.0159f
C2617 VPWR.n468 0 0.11119f
C2618 VPWR.n469 0 0.00477f
C2619 VPWR.t230 0 0.04179f
C2620 VPWR.n470 0 0.06565f
C2621 VPWR.n471 0 0.00626f
C2622 VPWR.n472 0 0.03181f
C2623 VPWR.n473 0 0.03181f
C2624 VPWR.n474 0 0.03181f
C2625 VPWR.n475 0 0.01104f
C2626 VPWR.n476 0 0.00661f
C2627 VPWR.t138 0 0.01552f
C2628 VPWR.t234 0 0.01628f
C2629 VPWR.n477 0 0.03243f
C2630 VPWR.n478 0 0.05087f
C2631 VPWR.n479 0 0.03181f
C2632 VPWR.n480 0 0.03181f
C2633 VPWR.n481 0 0.02352f
C2634 VPWR.n482 0 0.01092f
C2635 VPWR.n483 0 0.00667f
C2636 VPWR.n484 0 0.02386f
C2637 VPWR.n485 0 0.03181f
C2638 VPWR.n486 0 0.02684f
C2639 VPWR.n487 0 0.0077f
C2640 VPWR.t11 0 0.00533f
C2641 VPWR.t219 0 0.01335f
C2642 VPWR.n488 0 0.03807f
C2643 VPWR.n489 0 0.05894f
C2644 VPWR.n490 0 0.00913f
C2645 VPWR.n491 0 0.07702f
C2646 VPWR.n492 0 0.12145f
C2647 VPWR.n493 0 0.12426f
C2648 VPWR.n494 0 0.14761f
C2649 VPWR.n495 0 0.01183f
C2650 VPWR.n496 0 0.01121f
C2651 VPWR.n497 0 0.01073f
C2652 VPWR.n498 0 0.01104f
C2653 VPWR.n499 0 0.03181f
C2654 VPWR.n500 0 0.03181f
C2655 VPWR.n501 0 0.03181f
C2656 VPWR.n502 0 0.00782f
C2657 VPWR.t58 0 0.01623f
C2658 VPWR.n503 0 0.04771f
C2659 VPWR.n504 0 0.00782f
C2660 VPWR.n505 0 0.03181f
C2661 VPWR.n506 0 0.03181f
C2662 VPWR.n507 0 0.02386f
C2663 VPWR.n508 0 0.00989f
C2664 VPWR.n509 0 0.01104f
C2665 VPWR.n510 0 0.02386f
C2666 VPWR.n511 0 0.03181f
C2667 VPWR.n512 0 0.03181f
C2668 VPWR.t117 0 0.01761f
C2669 VPWR.t254 0 0.00293f
C2670 VPWR.n513 0 0.04689f
C2671 VPWR.n514 0 0.0637f
C2672 VPWR.n515 0 0.0104f
C2673 VPWR.n516 0 0.01104f
C2674 VPWR.n517 0 0.02386f
C2675 VPWR.n518 0 0.02386f
C2676 VPWR.n519 0 0.03181f
C2677 VPWR.n520 0 0.00563f
C2678 VPWR.n521 0 0.02549f
C2679 VPWR.n522 0 0.01043f
C2680 VPWR.n523 0 0.01181f
C2681 VPWR.n524 0 0.03181f
C2682 VPWR.n525 0 0.03181f
C2683 VPWR.n526 0 0.03181f
C2684 VPWR.n527 0 0.01104f
C2685 VPWR.n528 0 0.01104f
C2686 VPWR.n529 0 0.00956f
C2687 VPWR.n530 0 0.03181f
C2688 VPWR.n531 0 0.03181f
C2689 VPWR.n532 0 0.01121f
C2690 VPWR.n533 0 0.01073f
C2691 VPWR.n534 0 0.01104f
C2692 VPWR.n535 0 0.03181f
C2693 VPWR.n536 0 0.03181f
C2694 VPWR.n537 0 0.03181f
C2695 VPWR.n538 0 0.00782f
C2696 VPWR.t285 0 0.01623f
C2697 VPWR.n539 0 0.04771f
C2698 VPWR.n540 0 0.00782f
C2699 VPWR.n541 0 0.03181f
C2700 VPWR.n542 0 0.03181f
C2701 VPWR.n543 0 0.02386f
C2702 VPWR.n544 0 0.00989f
C2703 VPWR.n545 0 0.01104f
C2704 VPWR.n546 0 0.02386f
C2705 VPWR.n547 0 0.03181f
C2706 VPWR.n548 0 0.03181f
C2707 VPWR.t221 0 0.01761f
C2708 VPWR.t264 0 0.00293f
C2709 VPWR.n549 0 0.04689f
C2710 VPWR.n550 0 0.0637f
C2711 VPWR.n551 0 0.0104f
C2712 VPWR.n552 0 0.01104f
C2713 VPWR.n553 0 0.02386f
C2714 VPWR.n554 0 0.02386f
C2715 VPWR.n555 0 0.03181f
C2716 VPWR.n556 0 0.00563f
C2717 VPWR.n557 0 0.02549f
C2718 VPWR.n558 0 0.01043f
C2719 VPWR.n559 0 0.01181f
C2720 VPWR.n560 0 0.03181f
C2721 VPWR.n561 0 0.03181f
C2722 VPWR.n562 0 0.03181f
C2723 VPWR.n563 0 0.01104f
C2724 VPWR.n564 0 0.01104f
C2725 VPWR.n565 0 0.00956f
C2726 VPWR.n566 0 0.03181f
C2727 VPWR.n567 0 0.03181f
C2728 VPWR.n568 0 0.01121f
C2729 VPWR.n569 0 0.01073f
C2730 VPWR.n570 0 0.01104f
C2731 VPWR.n571 0 0.03181f
C2732 VPWR.n572 0 0.03181f
C2733 VPWR.n573 0 0.03181f
C2734 VPWR.n574 0 0.00782f
C2735 VPWR.t210 0 0.01623f
C2736 VPWR.n575 0 0.04771f
C2737 VPWR.n576 0 0.00782f
C2738 VPWR.n577 0 0.03181f
C2739 VPWR.n578 0 0.03181f
C2740 VPWR.n579 0 0.02386f
C2741 VPWR.n580 0 0.00989f
C2742 VPWR.n581 0 0.01104f
C2743 VPWR.n582 0 0.02386f
C2744 VPWR.n583 0 0.03181f
C2745 VPWR.n584 0 0.03181f
C2746 VPWR.t272 0 0.01761f
C2747 VPWR.t268 0 0.00293f
C2748 VPWR.n585 0 0.04689f
C2749 VPWR.n586 0 0.0637f
C2750 VPWR.n587 0 0.0104f
C2751 VPWR.n588 0 0.01104f
C2752 VPWR.n589 0 0.02386f
C2753 VPWR.n590 0 0.02386f
C2754 VPWR.n591 0 0.03181f
C2755 VPWR.n592 0 0.00563f
C2756 VPWR.n593 0 0.02549f
C2757 VPWR.n594 0 0.01043f
C2758 VPWR.n595 0 0.01181f
C2759 VPWR.n596 0 0.03181f
C2760 VPWR.n597 0 0.03181f
C2761 VPWR.n598 0 0.03181f
C2762 VPWR.n599 0 0.01104f
C2763 VPWR.n600 0 0.01104f
C2764 VPWR.n601 0 0.00956f
C2765 VPWR.n602 0 0.03181f
C2766 VPWR.n603 0 0.03181f
C2767 VPWR.n604 0 0.01121f
C2768 VPWR.n605 0 0.01073f
C2769 VPWR.n606 0 0.01104f
C2770 VPWR.n607 0 0.03181f
C2771 VPWR.n608 0 0.03181f
C2772 VPWR.n609 0 0.03181f
C2773 VPWR.n610 0 0.00782f
C2774 VPWR.t223 0 0.01623f
C2775 VPWR.n611 0 0.04771f
C2776 VPWR.n612 0 0.00782f
C2777 VPWR.n613 0 0.03181f
C2778 VPWR.n614 0 0.03181f
C2779 VPWR.n615 0 0.02386f
C2780 VPWR.n616 0 0.00989f
C2781 VPWR.n617 0 0.01104f
C2782 VPWR.n618 0 0.02386f
C2783 VPWR.n619 0 0.03181f
C2784 VPWR.n620 0 0.03181f
C2785 VPWR.t66 0 0.01761f
C2786 VPWR.t262 0 0.00293f
C2787 VPWR.n621 0 0.04689f
C2788 VPWR.n622 0 0.0637f
C2789 VPWR.n623 0 0.0104f
C2790 VPWR.n624 0 0.01104f
C2791 VPWR.n625 0 0.02386f
C2792 VPWR.n626 0 0.02386f
C2793 VPWR.n627 0 0.03181f
C2794 VPWR.n628 0 0.00563f
C2795 VPWR.n629 0 0.02549f
C2796 VPWR.n630 0 0.01043f
C2797 VPWR.n631 0 0.01181f
C2798 VPWR.n632 0 0.03181f
C2799 VPWR.n633 0 0.03181f
C2800 VPWR.n634 0 0.03181f
C2801 VPWR.n635 0 0.01104f
C2802 VPWR.n636 0 0.01104f
C2803 VPWR.n637 0 0.00956f
C2804 VPWR.n638 0 0.03181f
C2805 VPWR.n639 0 0.03181f
C2806 VPWR.n640 0 0.01121f
C2807 VPWR.n641 0 0.01073f
C2808 VPWR.n642 0 0.01104f
C2809 VPWR.n643 0 0.03181f
C2810 VPWR.n644 0 0.03181f
C2811 VPWR.n645 0 0.03181f
C2812 VPWR.n646 0 0.00782f
C2813 VPWR.t136 0 0.01623f
C2814 VPWR.n647 0 0.04771f
C2815 VPWR.n648 0 0.00782f
C2816 VPWR.n649 0 0.03181f
C2817 VPWR.n650 0 0.03181f
C2818 VPWR.n651 0 0.02386f
C2819 VPWR.n652 0 0.00989f
C2820 VPWR.n653 0 0.01104f
C2821 VPWR.n654 0 0.02386f
C2822 VPWR.n655 0 0.03181f
C2823 VPWR.n656 0 0.03181f
C2824 VPWR.t46 0 0.01761f
C2825 VPWR.t258 0 0.00293f
C2826 VPWR.n657 0 0.04689f
C2827 VPWR.n658 0 0.0637f
C2828 VPWR.n659 0 0.0104f
C2829 VPWR.n660 0 0.01104f
C2830 VPWR.n661 0 0.02386f
C2831 VPWR.n662 0 0.02386f
C2832 VPWR.n663 0 0.03181f
C2833 VPWR.n664 0 0.00563f
C2834 VPWR.n665 0 0.02549f
C2835 VPWR.n666 0 0.01043f
C2836 VPWR.n667 0 0.01181f
C2837 VPWR.n668 0 0.03181f
C2838 VPWR.n669 0 0.03181f
C2839 VPWR.n670 0 0.03181f
C2840 VPWR.n671 0 0.01104f
C2841 VPWR.n672 0 0.01104f
C2842 VPWR.n673 0 0.00956f
C2843 VPWR.n674 0 0.03181f
C2844 VPWR.n675 0 0.03181f
C2845 VPWR.n676 0 0.03181f
C2846 VPWR.n677 0 0.01073f
C2847 VPWR.n678 0 0.01104f
C2848 VPWR.n679 0 0.01104f
C2849 VPWR.n680 0 0.03181f
C2850 VPWR.n681 0 0.03181f
C2851 VPWR.n682 0 0.03181f
C2852 VPWR.t134 0 0.01623f
C2853 VPWR.n683 0 0.04771f
C2854 VPWR.n684 0 0.00782f
C2855 VPWR.t56 0 0.01263f
C2856 VPWR.t178 0 0.00852f
C2857 VPWR.n685 0 0.03332f
C2858 VPWR.n686 0 0.06494f
C2859 VPWR.n687 0 0.03181f
C2860 VPWR.n688 0 0.02386f
C2861 VPWR.n689 0 0.02386f
C2862 VPWR.n690 0 0.01104f
C2863 VPWR.n691 0 0.00787f
C2864 VPWR.t228 0 0.01761f
C2865 VPWR.t270 0 0.00293f
C2866 VPWR.n692 0 0.04689f
C2867 VPWR.n693 0 0.0637f
C2868 VPWR.n694 0 0.03181f
C2869 VPWR.n695 0 0.03181f
C2870 VPWR.n696 0 0.02386f
C2871 VPWR.n697 0 0.01104f
C2872 VPWR.n698 0 0.01104f
C2873 VPWR.n699 0 0.00563f
C2874 VPWR.n700 0 0.03181f
C2875 VPWR.n701 0 0.03181f
C2876 VPWR.n702 0 0.01043f
C2877 VPWR.n703 0 0.01181f
C2878 VPWR.t98 0 0.03321f
C2879 VPWR.n704 0 0.02038f
C2880 VPWR.n705 0 0.01004f
C2881 VPWR.n706 0 0.03181f
C2882 VPWR.n707 0 0.03181f
C2883 VPWR.n708 0 0.03181f
C2884 VPWR.n709 0 0.01104f
C2885 VPWR.n710 0 0.00956f
C2886 VPWR.t298 0 0.00433f
C2887 VPWR.t288 0 0.00795f
C2888 VPWR.n711 0 0.03818f
C2889 VPWR.n712 0 0.01499f
C2890 VPWR.n713 0 0.01121f
C2891 VPWR.n714 0 0.02104f
C2892 VPWR.n715 0 0.14235f
C2893 rst.t1 0 0.08428f
C2894 rst.t0 0 0.05017f
C2895 rst.n0 0 0.13419f
C2896 rst.t5 0 0.08428f
C2897 rst.t4 0 0.05017f
C2898 rst.n1 0 0.13399f
C2899 rst.n2 0 0.08527f
C2900 rst.t9 0 0.08428f
C2901 rst.t8 0 0.05017f
C2902 rst.n3 0 0.13386f
C2903 rst.n4 0 0.21549f
C2904 rst.t17 0 0.08428f
C2905 rst.t16 0 0.05017f
C2906 rst.n5 0 0.13447f
C2907 rst.n6 0 0.20755f
C2908 rst.n7 0 1.01116f
C2909 rst.t15 0 0.08428f
C2910 rst.t14 0 0.05017f
C2911 rst.n8 0 0.13395f
C2912 rst.n9 0 0.19915f
C2913 rst.n10 0 1.71402f
C2914 rst.t13 0 0.08428f
C2915 rst.t12 0 0.05017f
C2916 rst.n11 0 0.13386f
C2917 rst.n12 0 0.21664f
C2918 rst.n13 0 1.9402f
C2919 rst.t11 0 0.08428f
C2920 rst.t10 0 0.05017f
C2921 rst.n14 0 0.13386f
C2922 rst.n15 0 0.22723f
C2923 rst.n16 0 2.011f
C2924 rst.n17 0 1.92507f
C2925 rst.t7 0 0.08428f
C2926 rst.t6 0 0.05017f
C2927 rst.n18 0 0.13404f
C2928 rst.n19 0 0.08273f
C2929 rst.t3 0 0.08428f
C2930 rst.t2 0 0.05017f
C2931 rst.n20 0 0.13386f
C2932 rst.n21 0 0.53647f
C2933 rst.n22 0 1.33251f
C2934 rst.n23 0 1.58001f
C2935 rst.n24 0 1.66098f
C2936 rst.n25 0 0.22468f
C2937 clk.t1 0 0.06045f
C2938 clk.t0 0 0.04021f
C2939 clk.n0 0 0.10832f
C2940 clk.n1 0 0.18104f
C2941 clk.t5 0 0.06045f
C2942 clk.t4 0 0.04021f
C2943 clk.n2 0 0.10817f
C2944 clk.n3 0 0.08297f
C2945 clk.n4 0 1.02967f
C2946 clk.n5 0 0.51681f
C2947 clk.t3 0 0.06045f
C2948 clk.t2 0 0.04021f
C2949 clk.n6 0 0.10799f
C2950 clk.n7 0 0.20581f
C2951 clk.t7 0 0.06045f
C2952 clk.t6 0 0.04021f
C2953 clk.n8 0 0.10873f
C2954 clk.n9 0 0.08073f
C2955 clk.n10 0 0.91086f
C2956 clk.n11 0 0.91329f
C2957 clk.t9 0 0.06045f
C2958 clk.t8 0 0.04021f
C2959 clk.n12 0 0.10824f
C2960 clk.n13 0 0.20048f
C2961 clk.n14 0 1.17749f
C2962 clk.t11 0 0.06045f
C2963 clk.t10 0 0.04021f
C2964 clk.n15 0 0.10809f
C2965 clk.n16 0 0.20004f
C2966 clk.n17 0 1.231f
C2967 clk.t13 0 0.06045f
C2968 clk.t12 0 0.04021f
C2969 clk.n18 0 0.10802f
C2970 clk.n19 0 0.19839f
C2971 clk.n20 0 1.35334f
C2972 clk.t15 0 0.06045f
C2973 clk.t14 0 0.04021f
C2974 clk.n21 0 0.10799f
C2975 clk.n22 0 0.19595f
C2976 clk.n23 0 2.06643f
C2977 clk.t17 0 0.06045f
C2978 clk.t16 0 0.04021f
C2979 clk.n24 0 0.10799f
C2980 clk.n25 0 0.35221f
C2981 en.t3 0 0.04993f
C2982 en.t0 0 0.07489f
C2983 en.n0 0 0.04747f
C2984 en.n1 0 0.05735f
C2985 en.n2 0 0.25443f
C2986 en.t5 0 0.03474f
C2987 en.t4 0 0.05579f
C2988 en.t1 0 0.09636f
C2989 en.t2 0 0.0712f
C2990 en.n3 0 0.08394f
C2991 en.n4 0 0.05061f
C2992 overflow.t1 0 0.08256f
C2993 overflow.n0 0 0.11011f
C2994 overflow.n1 0 0.02784f
C2995 overflow.t0 0 0.03605f
C2996 overflow.n2 0 0.02046f
.ends
