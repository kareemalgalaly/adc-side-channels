* NGSPICE file created from layout_dig_flat.ext - technology: sky130A

.subckt layout_dig_flat rst VGND VPWR wenn clk counter.0 counter.1 counter.2 counter.3
+ counter.4 counter.5 counter.6 counter.7 reset_cycle
X0 VGND a_1775_2311# a_1793_1954# VGND sky130_fd_pr__nfet_01v8_lvt ad=0.1648 pd=1.245 as=0.0441 ps=0.63 w=0.42 l=0.15
X1 a_955_n1035# digital_layout1_0.sky130_fd_sc_hs__nand2b_1_0.Y VGND VGND sky130_fd_pr__nfet_01v8_lvt ad=0.0777 pd=0.95 as=0.1961 ps=2.01 w=0.74 l=0.15
X2 digital_layout1_0.sky130_fd_sc_hs__dfxtp_1_7.Q a_9148_n6817# VGND VGND sky130_fd_pr__nfet_01v8_lvt ad=0.2109 pd=2.05 as=0.1229 ps=1.085 w=0.74 l=0.15
X3 VGND a_3771_n6707# a_3970_n6817# VGND sky130_fd_pr__nfet_01v8_lvt ad=0.1229 pd=1.085 as=0.1824 ps=1.85 w=0.64 l=0.15
X4 a_n1461_2279# a_n2266_2223# a_n1759_2313# VGND sky130_fd_pr__nfet_01v8_lvt ad=0.1181 pd=1.035 as=0.10905 ps=1.025 w=0.55 l=0.15
X5 VGND clk a_n665_n7057# VGND sky130_fd_pr__nfet_01v8_lvt ad=0.1739 pd=1.21 as=0.2109 ps=2.05 w=0.74 l=0.15
X6 a_4964_n6247# digital_layout1_0.sky130_fd_sc_hs__mux2i_1_0.S VPWR VPWR sky130_fd_pr__pfet_01v8 ad=0.231 pd=2.23 as=0.2394 ps=2.25 w=0.84 l=0.15
X7 VPWR a_9755_n6209# digital_layout1_0.sky130_fd_sc_hs__nand2b_1_0.Y VPWR sky130_fd_pr__pfet_01v8 ad=0.336 pd=2.84 as=0.196 ps=1.47 w=1.12 l=0.15
X8 a_n200_n6247# digital_layout1_0.sky130_fd_sc_hs__mux2i_1_0.S VGND VGND sky130_fd_pr__nfet_01v8_lvt ad=0.15675 pd=1.67 as=0.15675 ps=1.67 w=0.55 l=0.15
X9 a_n3860_1261# rst VPWR VPWR sky130_fd_pr__pfet_01v8 ad=0.1512 pd=1.39 as=0.3304 ps=2.83 w=1.12 l=0.15
X10 a_6688_n6247# digital_layout1_0.sky130_fd_sc_hs__mux2i_1_0.S VGND VGND sky130_fd_pr__nfet_01v8_lvt ad=0.15675 pd=1.67 as=0.15675 ps=1.67 w=0.55 l=0.15
X11 VGND reset_cycle digital_layout1_0.sky130_fd_sc_hs__nor3b_1_3.Y VGND sky130_fd_pr__nfet_01v8_lvt ad=0.1554 pd=1.16 as=0.1184 ps=1.06 w=0.74 l=0.15
X12 a_10120_n6628# digital_layout1_0.sky130_fd_sc_hs__dfxtp_1_8.D VGND VGND sky130_fd_pr__nfet_01v8_lvt ad=0.15563 pd=1.215 as=0.23015 ps=2.1 w=0.42 l=0.15
X13 digital_layout1_0.sky130_fd_sc_hs__nand2b_1_0.Y digital_layout1_0.sky130_fd_sc_hs__mux2i_1_0.S VPWR VPWR sky130_fd_pr__pfet_01v8 ad=0.196 pd=1.47 as=0.2786 ps=1.64 w=1.12 l=0.15
X14 a_n1911_2318# a_n2266_2223# a_n2018_2358# VPWR sky130_fd_pr__pfet_01v8 ad=0.09835 pd=1.005 as=0.09835 ps=1.005 w=0.42 l=0.15
X15 sky130_fd_sc_hs__a211oi_1_6.A1 sky130_fd_sc_hs__inv_1_7.A VPWR VPWR sky130_fd_pr__pfet_01v8 ad=0.3304 pd=2.83 as=0.3864 ps=2.93 w=1.12 l=0.15
X16 VPWR digital_layout1_0.sky130_fd_sc_hs__mux2i_1_0.S a_5073_n5953# VPWR sky130_fd_pr__pfet_01v8 ad=0.168 pd=1.42 as=0.3136 ps=2.8 w=1.12 l=0.15
X17 VGND a_9143_2281# a_9342_2171# VGND sky130_fd_pr__nfet_01v8_lvt ad=0.1229 pd=1.085 as=0.1824 ps=1.85 w=0.64 l=0.15
X18 VPWR clk a_9693_n7057# VPWR sky130_fd_pr__pfet_01v8 ad=0.168 pd=1.42 as=0.3304 ps=2.83 w=1.12 l=0.15
X19 sky130_fd_sc_hs__mux2i_1_0.A0 a_12726_2169# VPWR VPWR sky130_fd_pr__pfet_01v8 ad=0.3304 pd=2.83 as=0.1862 ps=1.475 w=1.12 l=0.15
X20 digital_layout1_0.sky130_fd_sc_hs__dfxtp_1_1.Q a_n1210_n6817# VPWR VPWR sky130_fd_pr__pfet_01v8 ad=0.3304 pd=2.83 as=0.1862 ps=1.475 w=1.12 l=0.15
X21 a_6799_n6247# digital_layout1_0.sky130_fd_sc_hs__dfxtp_1_6.Q digital_layout1_0.sky130_fd_sc_hs__mux2i_1_6.Y VGND sky130_fd_pr__nfet_01v8_lvt ad=0.2109 pd=2.05 as=0.26085 ps=1.445 w=0.74 l=0.15
X22 VGND digital_layout1_0.sky130_fd_sc_hs__mux2i_1_0.S a_n3529_n6247# VGND sky130_fd_pr__nfet_01v8_lvt ad=0.1554 pd=1.16 as=0.2109 ps=2.05 w=0.74 l=0.15
X23 a_9404_n5953# reset_cycle a_9320_n5953# VPWR sky130_fd_pr__pfet_01v8 ad=0.2352 pd=1.54 as=0.1512 ps=1.39 w=1.12 l=0.15
X24 VGND digital_layout1_0.sky130_fd_sc_hs__mux2i_1_0.S a_3355_n6247# VGND sky130_fd_pr__nfet_01v8_lvt ad=0.1554 pd=1.16 as=0.2109 ps=2.05 w=0.74 l=0.15
X25 digital_layout1_0.sky130_fd_sc_hs__mux2i_1_6.Y counter.6 a_6797_n5953# VPWR sky130_fd_pr__pfet_01v8 ad=0.168 pd=1.42 as=0.3136 ps=2.8 w=1.12 l=0.15
X26 sky130_fd_sc_hs__inv_1_6.A a_9342_2171# VGND VGND sky130_fd_pr__nfet_01v8_lvt ad=0.2109 pd=2.05 as=0.1229 ps=1.085 w=0.74 l=0.15
X27 a_12247_1956# a_11722_2223# a_12077_2318# VGND sky130_fd_pr__nfet_01v8_lvt ad=0.0441 pd=0.63 as=0.07875 ps=0.865 w=0.42 l=0.15
X28 a_1767_n7030# a_1242_n6763# a_1597_n6668# VGND sky130_fd_pr__nfet_01v8_lvt ad=0.0441 pd=0.63 as=0.07875 ps=0.865 w=0.42 l=0.15
X29 a_426_n6623# a_n486_n6763# a_319_n6707# VPWR sky130_fd_pr__pfet_01v8 ad=0.09975 pd=0.895 as=0.1428 ps=1.225 w=0.42 l=0.15
X30 VPWR reset_cycle a_9755_n6209# VPWR sky130_fd_pr__pfet_01v8 ad=0.2786 pd=1.64 as=0.2478 ps=2.27 w=0.84 l=0.15
X31 VPWR digital_layout1_0.sky130_fd_sc_hs__inv_1_1.Y a_12209_1319# VPWR sky130_fd_pr__pfet_01v8 ad=0.168 pd=1.42 as=0.3136 ps=2.8 w=1.12 l=0.15
X32 a_12684_1979# a_11543_1929# a_12527_2279# VGND sky130_fd_pr__nfet_01v8_lvt ad=0.05565 pd=0.685 as=0.1181 ps=1.035 w=0.42 l=0.15
X33 digital_layout1_0.sky130_fd_sc_hs__dfxtp_1_8.D digital_layout1_0.sky130_fd_sc_hs__nor2_1_0.A VPWR VPWR sky130_fd_pr__pfet_01v8 ad=0.3304 pd=2.83 as=0.3864 ps=2.93 w=1.12 l=0.15
X34 a_n1859_n6668# a_n2393_n7057# a_n1966_n6628# VGND sky130_fd_pr__nfet_01v8_lvt ad=0.07875 pd=0.865 as=0.15563 ps=1.215 w=0.42 l=0.15
X35 sky130_fd_sc_hs__a211oi_1_2.Y rst a_1780_n741# VPWR sky130_fd_pr__pfet_01v8 ad=0.308 pd=2.79 as=0.1848 ps=1.45 w=1.12 l=0.15
X36 sky130_fd_sc_hs__mux2i_1_1.Y sky130_fd_sc_hs__mux2i_1_1.A0 a_n3465_1261# VPWR sky130_fd_pr__pfet_01v8 ad=0.168 pd=1.42 as=0.3136 ps=2.8 w=1.12 l=0.15
X37 a_9250_2365# a_8338_2225# a_9143_2281# VPWR sky130_fd_pr__pfet_01v8 ad=0.09975 pd=0.895 as=0.1428 ps=1.225 w=0.42 l=0.15
X38 a_n1924_n6247# digital_layout1_0.sky130_fd_sc_hs__mux2i_1_0.S VPWR VPWR sky130_fd_pr__pfet_01v8 ad=0.231 pd=2.23 as=0.2394 ps=2.25 w=0.84 l=0.15
X39 a_n1302_n6623# a_n2214_n6763# a_n1409_n6707# VPWR sky130_fd_pr__pfet_01v8 ad=0.09975 pd=0.895 as=0.1428 ps=1.225 w=0.42 l=0.15
X40 VGND reset_cycle digital_layout1_0.sky130_fd_sc_hs__nor3b_1_6.Y VGND sky130_fd_pr__nfet_01v8_lvt ad=0.1554 pd=1.16 as=0.1184 ps=1.06 w=0.74 l=0.15
X41 a_2972_2221# a_2793_1927# VPWR VPWR sky130_fd_pr__pfet_01v8 ad=0.3304 pd=2.83 as=0.168 ps=1.42 w=1.12 l=0.15
X42 VPWR a_518_n6817# a_426_n6623# VPWR sky130_fd_pr__pfet_01v8 ad=0.1239 pd=1.43 as=0.09975 ps=0.895 w=0.42 l=0.15
X43 a_n3476_n6628# a_n4117_n7057# a_n3583_n6668# VPWR sky130_fd_pr__pfet_01v8 ad=0.0504 pd=0.66 as=0.09835 ps=1.005 w=0.42 l=0.15
X44 a_3878_n6623# a_2966_n6763# a_3771_n6707# VPWR sky130_fd_pr__pfet_01v8 ad=0.09975 pd=0.895 as=0.1428 ps=1.225 w=0.42 l=0.15
X45 VGND digital_layout1_0.sky130_fd_sc_hs__mux2i_1_5.Y digital_layout1_0.sky130_fd_sc_hs__dfxtp_1_5.D VGND sky130_fd_pr__nfet_01v8_lvt ad=0.2109 pd=2.05 as=0.1036 ps=1.02 w=0.74 l=0.15
X46 a_1623_2316# a_1268_2221# a_1516_2356# VPWR sky130_fd_pr__pfet_01v8 ad=0.09835 pd=1.005 as=0.09835 ps=1.005 w=0.42 l=0.15
X47 a_476_n7007# a_n665_n7057# a_319_n6707# VGND sky130_fd_pr__nfet_01v8_lvt ad=0.05565 pd=0.685 as=0.1181 ps=1.035 w=0.42 l=0.15
X48 VPWR a_n3431_n6673# a_n3476_n6628# VPWR sky130_fd_pr__pfet_01v8 ad=0.18985 pd=1.545 as=0.0504 ps=0.66 w=0.42 l=0.15
X49 sky130_fd_sc_hs__a211oi_1_5.Y sky130_fd_sc_hs__a211oi_1_5.A1 a_2243_n1035# VGND sky130_fd_pr__nfet_01v8_lvt ad=0.1443 pd=1.13 as=0.0777 ps=0.95 w=0.74 l=0.15
X50 VPWR a_10876_n6817# a_10784_n6623# VPWR sky130_fd_pr__pfet_01v8 ad=0.1239 pd=1.43 as=0.09975 ps=0.895 w=0.42 l=0.15
X51 VPWR a_10379_n6673# a_10334_n6628# VPWR sky130_fd_pr__pfet_01v8 ad=0.18985 pd=1.545 as=0.0504 ps=0.66 w=0.42 l=0.15
X52 a_1490_n6628# digital_layout1_0.sky130_fd_sc_hs__dfxtp_1_3.D VPWR VPWR sky130_fd_pr__pfet_01v8 ad=0.09835 pd=1.005 as=0.2972 ps=2.41 w=0.42 l=0.15
X53 VPWR digital_layout1_0.sky130_fd_sc_hs__mux2i_1_0.S a_3921_n6209# VPWR sky130_fd_pr__pfet_01v8 ad=0.2177 pd=1.54 as=0.2478 ps=2.27 w=0.84 l=0.15
X54 a_1524_n6247# digital_layout1_0.sky130_fd_sc_hs__mux2i_1_0.S VPWR VPWR sky130_fd_pr__pfet_01v8 ad=0.231 pd=2.23 as=0.2394 ps=2.25 w=0.84 l=0.15
X55 VGND a_1749_n6673# a_1767_n7030# VGND sky130_fd_pr__nfet_01v8_lvt ad=0.1648 pd=1.245 as=0.0441 ps=0.63 w=0.42 l=0.15
X56 digital_layout1_0.sky130_fd_sc_hs__dfxtp_1_2.D digital_layout1_0.sky130_fd_sc_hs__mux2i_1_2.Y a_n486_n5953# VPWR sky130_fd_pr__pfet_01v8 ad=0.3304 pd=2.83 as=0.1512 ps=1.39 w=1.12 l=0.15
X57 a_2204_n7007# a_1063_n7057# a_2047_n6707# VGND sky130_fd_pr__nfet_01v8_lvt ad=0.05565 pd=0.685 as=0.1181 ps=1.035 w=0.42 l=0.15
X58 a_n89_n6247# digital_layout1_0.sky130_fd_sc_hs__dfxtp_1_2.Q digital_layout1_0.sky130_fd_sc_hs__mux2i_1_2.Y VGND sky130_fd_pr__nfet_01v8_lvt ad=0.2109 pd=2.05 as=0.26085 ps=1.445 w=0.74 l=0.15
X59 VGND digital_layout1_0.sky130_fd_sc_hs__nor3b_1_0.Y sky130_fd_sc_hs__a211oi_1_0.Y VGND sky130_fd_pr__nfet_01v8_lvt ad=0.1443 pd=1.13 as=0.1443 ps=1.13 w=0.74 l=0.15
X60 a_n3355_n5953# a_n3640_n6247# VPWR VPWR sky130_fd_pr__pfet_01v8 ad=0.308 pd=2.79 as=0.168 ps=1.42 w=1.12 l=0.15
X61 digital_layout1_0.sky130_fd_sc_hs__mux2i_1_2.Y counter.2 a_n91_n5953# VPWR sky130_fd_pr__pfet_01v8 ad=0.168 pd=1.42 as=0.3136 ps=2.8 w=1.12 l=0.15
X62 a_6420_n6763# a_6241_n7057# VPWR VPWR sky130_fd_pr__pfet_01v8 ad=0.3304 pd=2.83 as=0.168 ps=1.42 w=1.12 l=0.15
X63 VGND clk a_1089_1927# VGND sky130_fd_pr__nfet_01v8_lvt ad=0.1739 pd=1.21 as=0.2109 ps=2.05 w=0.74 l=0.15
X64 VGND a_10677_n6707# a_10876_n6817# VGND sky130_fd_pr__nfet_01v8_lvt ad=0.1229 pd=1.085 as=0.1824 ps=1.85 w=0.64 l=0.15
X65 VPWR a_2073_2277# a_2272_2167# VPWR sky130_fd_pr__pfet_01v8 ad=0.1862 pd=1.475 as=0.2478 ps=2.27 w=0.84 l=0.15
X66 wenn a_12779_1063# a_13030_1319# VPWR sky130_fd_pr__pfet_01v8 ad=0.42 pd=2.99 as=0.1512 ps=1.39 w=1.12 l=0.15
X67 a_3591_n1031# digital_layout1_0.sky130_fd_sc_hs__nand2b_1_0.Y VGND VGND sky130_fd_pr__nfet_01v8_lvt ad=0.0777 pd=0.95 as=0.1961 ps=2.01 w=0.74 l=0.15
X68 a_6668_n6628# digital_layout1_0.sky130_fd_sc_hs__dfxtp_1_6.D VGND VGND sky130_fd_pr__nfet_01v8_lvt ad=0.15563 pd=1.215 as=0.23015 ps=2.1 w=0.42 l=0.15
X69 digital_layout1_0.sky130_fd_sc_hs__dfxtp_1_8.D digital_layout1_0.sky130_fd_sc_hs__nor2_1_0.A VGND VGND sky130_fd_pr__nfet_01v8_lvt ad=0.2109 pd=2.05 as=0.2627 ps=2.19 w=0.74 l=0.15
X70 a_7600_n5953# counter.6 VPWR VPWR sky130_fd_pr__pfet_01v8 ad=0.1512 pd=1.39 as=0.2177 ps=1.54 w=1.12 l=0.15
X71 VPWR a_8949_n6707# a_9148_n6817# VPWR sky130_fd_pr__pfet_01v8 ad=0.1862 pd=1.475 as=0.2478 ps=2.27 w=0.84 l=0.15
X72 a_3529_n5953# a_3244_n6247# VPWR VPWR sky130_fd_pr__pfet_01v8 ad=0.308 pd=2.79 as=0.168 ps=1.42 w=1.12 l=0.15
X73 VGND digital_layout1_0.sky130_fd_sc_hs__mux2i_1_0.S a_n1813_n6247# VGND sky130_fd_pr__nfet_01v8_lvt ad=0.1554 pd=1.16 as=0.2109 ps=2.05 w=0.74 l=0.15
X74 a_12385_1319# a_12100_1025# VPWR VPWR sky130_fd_pr__pfet_01v8 ad=0.308 pd=2.79 as=0.168 ps=1.42 w=1.12 l=0.15
X75 a_3503_n737# sky130_fd_sc_hs__a211oi_1_7.A1 VPWR VPWR sky130_fd_pr__pfet_01v8 ad=0.168 pd=1.42 as=0.2184 ps=1.51 w=1.12 l=0.15
X76 digital_layout1_0.sky130_fd_sc_hs__nor3b_1_6.Y counter.6 VGND VGND sky130_fd_pr__nfet_01v8_lvt ad=0.1184 pd=1.06 as=0.13717 ps=1.13 w=0.74 l=0.15
X77 a_n2018_2358# sky130_fd_sc_hs__a211oi_1_0.Y VPWR VPWR sky130_fd_pr__pfet_01v8 ad=0.09835 pd=1.005 as=0.2972 ps=2.41 w=0.42 l=0.15
X78 sky130_fd_sc_hs__a211oi_1_0.Y rst VGND VGND sky130_fd_pr__nfet_01v8_lvt ad=0.1961 pd=2.01 as=0.1443 ps=1.13 w=0.74 l=0.15
X79 VPWR a_12229_2313# a_12184_2358# VPWR sky130_fd_pr__pfet_01v8 ad=0.18985 pd=1.545 as=0.0504 ps=0.66 w=0.42 l=0.15
X80 a_4223_n1031# digital_layout1_0.sky130_fd_sc_hs__nand2b_1_0.Y VGND VGND sky130_fd_pr__nfet_01v8_lvt ad=0.0777 pd=0.95 as=0.1961 ps=2.01 w=0.74 l=0.15
X81 sky130_fd_sc_hs__a211oi_1_2.Y rst VGND VGND sky130_fd_pr__nfet_01v8_lvt ad=0.1961 pd=2.01 as=0.1443 ps=1.13 w=0.74 l=0.15
X82 digital_layout1_0.sky130_fd_sc_hs__nor3b_1_0.Y a_n2967_n6209# a_n2650_n5953# VPWR sky130_fd_pr__pfet_01v8 ad=0.3304 pd=2.83 as=0.2352 ps=1.54 w=1.12 l=0.15
X83 a_6668_n6628# digital_layout1_0.sky130_fd_sc_hs__dfxtp_1_6.D VPWR VPWR sky130_fd_pr__pfet_01v8 ad=0.09835 pd=1.005 as=0.2972 ps=2.41 w=0.42 l=0.15
X84 a_6962_2360# a_6321_1931# a_6855_2320# VPWR sky130_fd_pr__pfet_01v8 ad=0.0504 pd=0.66 as=0.09835 ps=1.005 w=0.42 l=0.15
X85 wenn sky130_fd_sc_hs__mux2i_1_0.A0 VGND VGND sky130_fd_pr__nfet_01v8_lvt ad=0.13135 pd=1.095 as=0.15358 ps=1.2 w=0.74 l=0.15
X86 a_6855_2320# a_6500_2225# a_6748_2360# VPWR sky130_fd_pr__pfet_01v8 ad=0.09835 pd=1.005 as=0.09835 ps=1.005 w=0.42 l=0.15
X87 VPWR a_7424_n6817# a_7332_n6623# VPWR sky130_fd_pr__pfet_01v8 ad=0.1239 pd=1.43 as=0.09975 ps=0.895 w=0.42 l=0.15
X88 VGND digital_layout1_0.sky130_fd_sc_hs__mux2i_1_0.Y digital_layout1_0.sky130_fd_sc_hs__dfxtp_1_0.D VGND sky130_fd_pr__nfet_01v8_lvt ad=0.2109 pd=2.05 as=0.1036 ps=1.02 w=0.74 l=0.15
X89 sky130_fd_sc_hs__inv_1_0.A a_n1262_2169# VPWR VPWR sky130_fd_pr__pfet_01v8 ad=0.3304 pd=2.83 as=0.1862 ps=1.475 w=1.12 l=0.15
X90 VGND digital_layout1_0.sky130_fd_sc_hs__nor3b_1_2.Y sky130_fd_sc_hs__a211oi_1_3.Y VGND sky130_fd_pr__nfet_01v8_lvt ad=0.1443 pd=1.13 as=0.1443 ps=1.13 w=0.74 l=0.15
X91 VGND digital_layout1_0.sky130_fd_sc_hs__mux2i_1_3.Y digital_layout1_0.sky130_fd_sc_hs__dfxtp_1_3.D VGND sky130_fd_pr__nfet_01v8_lvt ad=0.2109 pd=2.05 as=0.1036 ps=1.02 w=0.74 l=0.15
X92 VGND a_11036_2169# a_10994_1979# VGND sky130_fd_pr__nfet_01v8_lvt ad=0.1197 pd=1.41 as=0.05565 ps=0.685 w=0.42 l=0.15
X93 VPWR digital_layout1_0.sky130_fd_sc_hs__nand2b_1_0.Y a_3503_n737# VPWR sky130_fd_pr__pfet_01v8 ad=0.2184 pd=1.51 as=0.308 ps=2.79 w=1.12 l=0.15
X94 a_8697_n5953# a_8412_n6247# VPWR VPWR sky130_fd_pr__pfet_01v8 ad=0.308 pd=2.79 as=0.168 ps=1.42 w=1.12 l=0.15
X95 sky130_fd_sc_hs__a211oi_1_7.Y sky130_fd_sc_hs__a211oi_1_7.A1 a_3591_n1031# VGND sky130_fd_pr__nfet_01v8_lvt ad=0.1443 pd=1.13 as=0.0777 ps=0.95 w=0.74 l=0.15
X96 a_3771_n6707# a_2966_n6763# a_3473_n6673# VGND sky130_fd_pr__nfet_01v8_lvt ad=0.1181 pd=1.035 as=0.10905 ps=1.025 w=0.55 l=0.15
X97 a_n3147_2281# a_n4131_1931# a_n3445_2315# VPWR sky130_fd_pr__pfet_01v8 ad=0.1428 pd=1.225 as=0.2331 ps=1.395 w=0.84 l=0.15
X98 a_5712_2365# a_4800_2225# a_5605_2281# VPWR sky130_fd_pr__pfet_01v8 ad=0.09975 pd=0.895 as=0.1428 ps=1.225 w=0.42 l=0.15
X99 a_3934_1977# a_2793_1927# a_3777_2277# VGND sky130_fd_pr__nfet_01v8_lvt ad=0.05565 pd=0.685 as=0.1181 ps=1.035 w=0.42 l=0.15
X100 a_319_n6707# a_n665_n7057# a_21_n6673# VPWR sky130_fd_pr__pfet_01v8 ad=0.1428 pd=1.225 as=0.2331 ps=1.395 w=0.84 l=0.15
X101 a_85_n5953# a_n200_n6247# VPWR VPWR sky130_fd_pr__pfet_01v8 ad=0.308 pd=2.79 as=0.168 ps=1.42 w=1.12 l=0.15
X102 a_n3445_2315# a_n3597_2320# VGND VGND sky130_fd_pr__nfet_01v8_lvt ad=0.10905 pd=1.025 as=0.1648 ps=1.245 w=0.55 l=0.15
X103 a_10784_n6623# a_9872_n6763# a_10677_n6707# VPWR sky130_fd_pr__pfet_01v8 ad=0.09975 pd=0.895 as=0.1428 ps=1.225 w=0.42 l=0.15
X104 VPWR clk a_2787_n7057# VPWR sky130_fd_pr__pfet_01v8 ad=0.168 pd=1.42 as=0.3304 ps=2.83 w=1.12 l=0.15
X105 a_n1639_n5953# a_n1924_n6247# VPWR VPWR sky130_fd_pr__pfet_01v8 ad=0.308 pd=2.79 as=0.168 ps=1.42 w=1.12 l=0.15
X106 VGND a_n3445_2315# a_n3427_1958# VGND sky130_fd_pr__nfet_01v8_lvt ad=0.1648 pd=1.245 as=0.0441 ps=0.63 w=0.42 l=0.15
X107 VPWR a_n1262_2169# a_n1354_2363# VPWR sky130_fd_pr__pfet_01v8 ad=0.1239 pd=1.43 as=0.09975 ps=0.895 w=0.42 l=0.15
X108 a_10837_2279# a_10032_2223# a_10539_2313# VGND sky130_fd_pr__nfet_01v8_lvt ad=0.1181 pd=1.035 as=0.10905 ps=1.025 w=0.55 l=0.15
X109 sky130_fd_sc_hs__a211oi_1_6.Y sky130_fd_sc_hs__a211oi_1_6.A1 a_4223_n1031# VGND sky130_fd_pr__nfet_01v8_lvt ad=0.1443 pd=1.13 as=0.0777 ps=0.95 w=0.74 l=0.15
X110 a_4942_n6628# digital_layout1_0.sky130_fd_sc_hs__dfxtp_1_5.D VGND VGND sky130_fd_pr__nfet_01v8_lvt ad=0.15563 pd=1.215 as=0.23015 ps=2.1 w=0.42 l=0.15
X111 a_5075_n6247# digital_layout1_0.sky130_fd_sc_hs__dfxtp_1_5.Q digital_layout1_0.sky130_fd_sc_hs__mux2i_1_5.Y VGND sky130_fd_pr__nfet_01v8_lvt ad=0.2109 pd=2.05 as=0.26085 ps=1.445 w=0.74 l=0.15
X112 a_5962_n5953# reset_cycle a_5878_n5953# VPWR sky130_fd_pr__pfet_01v8 ad=0.2352 pd=1.54 as=0.1512 ps=1.39 w=1.12 l=0.15
X113 a_3786_n737# digital_layout1_0.sky130_fd_sc_hs__nor3b_1_6.Y a_3503_n737# VPWR sky130_fd_pr__pfet_01v8 ad=0.1848 pd=1.45 as=0.168 ps=1.42 w=1.12 l=0.15
X114 a_n24_n6628# a_n665_n7057# a_n131_n6668# VPWR sky130_fd_pr__pfet_01v8 ad=0.0504 pd=0.66 as=0.09835 ps=1.005 w=0.42 l=0.15
X115 digital_layout1_0.sky130_fd_sc_hs__nor3b_1_0.Y a_n2967_n6209# VGND VGND sky130_fd_pr__nfet_01v8_lvt ad=0.2109 pd=2.05 as=0.1554 ps=1.16 w=0.74 l=0.15
X116 a_2073_2277# a_1268_2221# a_1775_2311# VGND sky130_fd_pr__nfet_01v8_lvt ad=0.1181 pd=1.035 as=0.10905 ps=1.025 w=0.55 l=0.15
X117 a_5606_n6623# a_4694_n6763# a_5499_n6707# VPWR sky130_fd_pr__pfet_01v8 ad=0.09975 pd=0.895 as=0.1428 ps=1.225 w=0.42 l=0.15
X118 a_n3490_2360# a_n4131_1931# a_n3597_2320# VPWR sky130_fd_pr__pfet_01v8 ad=0.0504 pd=0.66 as=0.09835 ps=1.005 w=0.42 l=0.15
X119 a_8338_2225# a_8159_1931# VGND VGND sky130_fd_pr__nfet_01v8_lvt ad=0.2553 pd=2.17 as=0.1739 ps=1.21 w=0.74 l=0.15
X120 a_3244_n6247# digital_layout1_0.sky130_fd_sc_hs__mux2i_1_0.S VPWR VPWR sky130_fd_pr__pfet_01v8 ad=0.231 pd=2.23 as=0.2394 ps=2.25 w=0.84 l=0.15
X121 sky130_fd_sc_hs__a211oi_1_7.A1 sky130_fd_sc_hs__inv_1_6.A VPWR VPWR sky130_fd_pr__pfet_01v8 ad=0.3304 pd=2.83 as=0.3864 ps=2.93 w=1.12 l=0.15
X122 digital_layout1_0.sky130_fd_sc_hs__dfxtp_1_6.Q a_7424_n6817# VPWR VPWR sky130_fd_pr__pfet_01v8 ad=0.3304 pd=2.83 as=0.1862 ps=1.475 w=1.12 l=0.15
X123 a_n2266_2223# a_n2445_1929# VPWR VPWR sky130_fd_pr__pfet_01v8 ad=0.3304 pd=2.83 as=0.168 ps=1.42 w=1.12 l=0.15
X124 a_9143_2281# a_8159_1931# a_8845_2315# VPWR sky130_fd_pr__pfet_01v8 ad=0.1428 pd=1.225 as=0.2331 ps=1.395 w=0.84 l=0.15
X125 VGND a_8651_n6673# a_8669_n7030# VGND sky130_fd_pr__nfet_01v8_lvt ad=0.1648 pd=1.245 as=0.0441 ps=0.63 w=0.42 l=0.15
X126 a_10834_n7007# a_9693_n7057# a_10677_n6707# VGND sky130_fd_pr__nfet_01v8_lvt ad=0.05565 pd=0.685 as=0.1181 ps=1.035 w=0.42 l=0.15
X127 a_4942_n6628# digital_layout1_0.sky130_fd_sc_hs__dfxtp_1_5.D VPWR VPWR sky130_fd_pr__pfet_01v8 ad=0.09835 pd=1.005 as=0.2972 ps=2.41 w=0.42 l=0.15
X128 a_n1707_n6673# a_n1859_n6668# VPWR VPWR sky130_fd_pr__pfet_01v8 ad=0.2331 pd=1.395 as=0.18985 ps=1.545 w=0.84 l=0.15
X129 digital_layout1_0.sky130_fd_sc_hs__dfxtp_1_0.Q a_n2934_n6817# VGND VGND sky130_fd_pr__nfet_01v8_lvt ad=0.2109 pd=2.05 as=0.1229 ps=1.085 w=0.74 l=0.15
X130 a_n205_2318# a_n739_1929# a_n312_2358# VGND sky130_fd_pr__nfet_01v8_lvt ad=0.07875 pd=0.865 as=0.15563 ps=1.215 w=0.42 l=0.15
X131 VPWR a_5698_n6817# a_5606_n6623# VPWR sky130_fd_pr__pfet_01v8 ad=0.1239 pd=1.43 as=0.09975 ps=0.895 w=0.42 l=0.15
X132 digital_layout1_0.sky130_fd_sc_hs__nor3b_1_2.Y a_477_n6209# VGND VGND sky130_fd_pr__nfet_01v8_lvt ad=0.2109 pd=2.05 as=0.1554 ps=1.16 w=0.74 l=0.15
X133 a_n35_1956# a_n560_2223# a_n205_2318# VGND sky130_fd_pr__nfet_01v8_lvt ad=0.0441 pd=0.63 as=0.07875 ps=0.865 w=0.42 l=0.15
X134 a_n1752_n6628# a_n2393_n7057# a_n1859_n6668# VPWR sky130_fd_pr__pfet_01v8 ad=0.0504 pd=0.66 as=0.09835 ps=1.005 w=0.42 l=0.15
X135 a_n560_2223# a_n739_1929# VPWR VPWR sky130_fd_pr__pfet_01v8 ad=0.3304 pd=2.83 as=0.168 ps=1.42 w=1.12 l=0.15
X136 a_8949_n6707# a_8144_n6763# a_8651_n6673# VGND sky130_fd_pr__nfet_01v8_lvt ad=0.1181 pd=1.035 as=0.10905 ps=1.025 w=0.55 l=0.15
X137 VGND digital_layout1_0.sky130_fd_sc_hs__nor3b_1_1.Y sky130_fd_sc_hs__a211oi_1_1.Y VGND sky130_fd_pr__nfet_01v8_lvt ad=0.1443 pd=1.13 as=0.1443 ps=1.13 w=0.74 l=0.15
X138 a_5656_n7007# a_4515_n7057# a_5499_n6707# VGND sky130_fd_pr__nfet_01v8_lvt ad=0.05565 pd=0.685 as=0.1181 ps=1.035 w=0.42 l=0.15
X139 a_5249_n5953# a_4964_n6247# VPWR VPWR sky130_fd_pr__pfet_01v8 ad=0.308 pd=2.79 as=0.168 ps=1.42 w=1.12 l=0.15
X140 a_9872_n6763# a_9693_n7057# VPWR VPWR sky130_fd_pr__pfet_01v8 ad=0.3304 pd=2.83 as=0.168 ps=1.42 w=1.12 l=0.15
X141 sky130_fd_sc_hs__inv_1_7.A a_11036_2169# VPWR VPWR sky130_fd_pr__pfet_01v8 ad=0.3304 pd=2.83 as=0.1862 ps=1.475 w=1.12 l=0.15
X142 a_3321_n6668# a_2787_n7057# a_3214_n6628# VGND sky130_fd_pr__nfet_01v8_lvt ad=0.07875 pd=0.865 as=0.15563 ps=1.215 w=0.42 l=0.15
X143 a_1516_2356# sky130_fd_sc_hs__a211oi_1_3.Y VGND VGND sky130_fd_pr__nfet_01v8_lvt ad=0.15563 pd=1.215 as=0.23015 ps=2.1 w=0.42 l=0.15
X144 VGND clk a_11543_1929# VGND sky130_fd_pr__nfet_01v8_lvt ad=0.1739 pd=1.21 as=0.2109 ps=2.05 w=0.74 l=0.15
X145 a_n3445_2315# a_n3597_2320# VPWR VPWR sky130_fd_pr__pfet_01v8 ad=0.2331 pd=1.395 as=0.18985 ps=1.545 w=0.84 l=0.15
X146 VPWR a_12527_2279# a_12726_2169# VPWR sky130_fd_pr__pfet_01v8 ad=0.1862 pd=1.475 as=0.2478 ps=2.27 w=0.84 l=0.15
X147 a_7332_n6623# a_6420_n6763# a_7225_n6707# VPWR sky130_fd_pr__pfet_01v8 ad=0.09975 pd=0.895 as=0.1428 ps=1.225 w=0.42 l=0.15
X148 VGND digital_layout1_0.sky130_fd_sc_hs__mux2i_1_0.S a_3921_n6209# VGND sky130_fd_pr__nfet_01v8_lvt ad=0.13717 pd=1.13 as=0.2695 ps=2.08 w=0.55 l=0.15
X149 a_6973_n5953# digital_layout1_0.sky130_fd_sc_hs__dfxtp_1_6.Q digital_layout1_0.sky130_fd_sc_hs__mux2i_1_6.Y VPWR sky130_fd_pr__pfet_01v8 ad=0.3192 pd=2.81 as=0.168 ps=1.42 w=1.12 l=0.15
X150 VGND a_12527_2279# a_12726_2169# VGND sky130_fd_pr__nfet_01v8_lvt ad=0.1229 pd=1.085 as=0.1824 ps=1.85 w=0.64 l=0.15
X151 digital_layout1_0.sky130_fd_sc_hs__mux2i_1_7.Y counter.7 a_8724_n6247# VGND sky130_fd_pr__nfet_01v8_lvt ad=0.26085 pd=1.445 as=0.0888 ps=0.98 w=0.74 l=0.15
X152 a_794_n5953# reset_cycle a_710_n5953# VPWR sky130_fd_pr__pfet_01v8 ad=0.2352 pd=1.54 as=0.1512 ps=1.39 w=1.12 l=0.15
X153 a_6748_2360# sky130_fd_sc_hs__a211oi_1_4.Y VGND VGND sky130_fd_pr__nfet_01v8_lvt ad=0.15563 pd=1.215 as=0.23015 ps=2.1 w=0.42 l=0.15
X154 a_10557_1956# a_10032_2223# a_10387_2318# VGND sky130_fd_pr__nfet_01v8_lvt ad=0.0441 pd=0.63 as=0.07875 ps=0.865 w=0.42 l=0.15
X155 digital_layout1_0.sky130_fd_sc_hs__dfxtp_1_7.D digital_layout1_0.sky130_fd_sc_hs__mux2i_1_7.Y a_8126_n5953# VPWR sky130_fd_pr__pfet_01v8 ad=0.3304 pd=2.83 as=0.1512 ps=1.39 w=1.12 l=0.15
X156 a_10994_1979# a_9853_1929# a_10837_2279# VGND sky130_fd_pr__nfet_01v8_lvt ad=0.05565 pd=0.685 as=0.1181 ps=1.035 w=0.42 l=0.15
X157 VGND clk a_n2393_n7057# VGND sky130_fd_pr__nfet_01v8_lvt ad=0.1739 pd=1.21 as=0.2109 ps=2.05 w=0.74 l=0.15
X158 VGND a_5605_2281# a_5804_2171# VGND sky130_fd_pr__nfet_01v8_lvt ad=0.1229 pd=1.085 as=0.1824 ps=1.85 w=0.64 l=0.15
X159 a_10280_2358# sky130_fd_sc_hs__a211oi_1_6.Y VPWR VPWR sky130_fd_pr__pfet_01v8 ad=0.09835 pd=1.005 as=0.2972 ps=2.41 w=0.42 l=0.15
X160 a_8724_n6247# a_8412_n6247# VGND VGND sky130_fd_pr__nfet_01v8_lvt ad=0.0888 pd=0.98 as=0.1554 ps=1.16 w=0.74 l=0.15
X161 a_10032_2223# a_9853_1929# VPWR VPWR sky130_fd_pr__pfet_01v8 ad=0.3304 pd=2.83 as=0.168 ps=1.42 w=1.12 l=0.15
X162 a_5878_n5953# counter.5 VPWR VPWR sky130_fd_pr__pfet_01v8 ad=0.1512 pd=1.39 as=0.2177 ps=1.54 w=1.12 l=0.15
X163 VGND digital_layout1_0.sky130_fd_sc_hs__mux2i_1_4.Y digital_layout1_0.sky130_fd_sc_hs__dfxtp_1_4.D VGND sky130_fd_pr__nfet_01v8_lvt ad=0.2109 pd=2.05 as=0.1036 ps=1.02 w=0.74 l=0.15
X164 VPWR digital_layout1_0.sky130_fd_sc_hs__mux2i_1_0.S a_1633_n5953# VPWR sky130_fd_pr__pfet_01v8 ad=0.168 pd=1.42 as=0.3136 ps=2.8 w=1.12 l=0.15
X165 sky130_fd_sc_hs__mux2i_1_0.Y sky130_fd_sc_hs__mux2i_1_0.A0 a_12412_1025# VGND sky130_fd_pr__nfet_01v8_lvt ad=0.26085 pd=1.445 as=0.0888 ps=0.98 w=0.74 l=0.15
X166 a_n131_n6668# a_n486_n6763# a_n238_n6628# VPWR sky130_fd_pr__pfet_01v8 ad=0.09835 pd=1.005 as=0.09835 ps=1.005 w=0.42 l=0.15
X167 a_112_n6247# a_n200_n6247# VGND VGND sky130_fd_pr__nfet_01v8_lvt ad=0.0888 pd=0.98 as=0.1554 ps=1.16 w=0.74 l=0.15
X168 sky130_fd_sc_hs__a211oi_1_1.A1 sky130_fd_sc_hs__inv_1_1.A VGND VGND sky130_fd_pr__nfet_01v8_lvt ad=0.2109 pd=2.05 as=0.2627 ps=2.19 w=0.74 l=0.15
X169 a_1242_n6763# a_1063_n7057# VGND VGND sky130_fd_pr__nfet_01v8_lvt ad=0.2553 pd=2.17 as=0.1739 ps=1.21 w=0.74 l=0.15
X170 sky130_fd_sc_hs__inv_1_4.A a_5804_2171# VGND VGND sky130_fd_pr__nfet_01v8_lvt ad=0.2109 pd=2.05 as=0.1229 ps=1.085 w=0.74 l=0.15
X171 VGND reset_cycle a_10271_n5953# VGND sky130_fd_pr__nfet_01v8_lvt ad=0.15198 pd=1.17 as=0.13062 ps=1.025 w=0.55 l=0.15
X172 sky130_fd_sc_hs__a211oi_1_1.Y rst a_504_n737# VPWR sky130_fd_pr__pfet_01v8 ad=0.308 pd=2.79 as=0.1848 ps=1.45 w=1.12 l=0.15
X173 a_n1409_n6707# a_n2214_n6763# a_n1707_n6673# VGND sky130_fd_pr__nfet_01v8_lvt ad=0.1181 pd=1.035 as=0.10905 ps=1.025 w=0.55 l=0.15
X174 digital_layout1_0.sky130_fd_sc_hs__dfxtp_1_4.Q a_3970_n6817# VGND VGND sky130_fd_pr__nfet_01v8_lvt ad=0.2109 pd=2.05 as=0.1229 ps=1.085 w=0.74 l=0.15
X175 VPWR clk a_n2445_1929# VPWR sky130_fd_pr__pfet_01v8 ad=0.168 pd=1.42 as=0.3304 ps=2.83 w=1.12 l=0.15
X176 VGND a_n1262_2169# a_n1304_1979# VGND sky130_fd_pr__nfet_01v8_lvt ad=0.1197 pd=1.41 as=0.05565 ps=0.685 w=0.42 l=0.15
X177 VPWR a_245_2279# a_444_2169# VPWR sky130_fd_pr__pfet_01v8 ad=0.1862 pd=1.475 as=0.2478 ps=2.27 w=0.84 l=0.15
X178 a_2785_n739# sky130_fd_sc_hs__a211oi_1_4.A1 VPWR VPWR sky130_fd_pr__pfet_01v8 ad=0.168 pd=1.42 as=0.2184 ps=1.51 w=1.12 l=0.15
X179 a_n3431_n6673# a_n3583_n6668# VGND VGND sky130_fd_pr__nfet_01v8_lvt ad=0.10905 pd=1.025 as=0.1648 ps=1.245 w=0.55 l=0.15
X180 a_n53_2313# a_n205_2318# VPWR VPWR sky130_fd_pr__pfet_01v8 ad=0.2331 pd=1.395 as=0.18985 ps=1.545 w=0.84 l=0.15
X181 VPWR clk a_n739_1929# VPWR sky130_fd_pr__pfet_01v8 ad=0.168 pd=1.42 as=0.3304 ps=2.83 w=1.12 l=0.15
X182 VPWR a_6927_n6673# a_6882_n6628# VPWR sky130_fd_pr__pfet_01v8 ad=0.18985 pd=1.545 as=0.0504 ps=0.66 w=0.42 l=0.15
X183 a_12184_2358# a_11543_1929# a_12077_2318# VPWR sky130_fd_pr__pfet_01v8 ad=0.0504 pd=0.66 as=0.09835 ps=1.005 w=0.42 l=0.15
X184 VPWR digital_layout1_0.sky130_fd_sc_hs__mux2i_1_0.S a_n3531_n5953# VPWR sky130_fd_pr__pfet_01v8 ad=0.168 pd=1.42 as=0.3136 ps=2.8 w=1.12 l=0.15
X185 a_8863_1958# a_8338_2225# a_8693_2320# VGND sky130_fd_pr__nfet_01v8_lvt ad=0.0441 pd=0.63 as=0.07875 ps=0.865 w=0.42 l=0.15
X186 a_12077_2318# a_11722_2223# a_11970_2358# VPWR sky130_fd_pr__pfet_01v8 ad=0.09835 pd=1.005 as=0.09835 ps=1.005 w=0.42 l=0.15
X187 a_85_n5953# digital_layout1_0.sky130_fd_sc_hs__dfxtp_1_2.Q digital_layout1_0.sky130_fd_sc_hs__mux2i_1_2.Y VPWR sky130_fd_pr__pfet_01v8 ad=0.3192 pd=2.81 as=0.168 ps=1.42 w=1.12 l=0.15
X188 a_n3640_n6247# digital_layout1_0.sky130_fd_sc_hs__mux2i_1_0.S VPWR VPWR sky130_fd_pr__pfet_01v8 ad=0.231 pd=2.23 as=0.2394 ps=2.25 w=0.84 l=0.15
X189 a_6882_n6628# a_6241_n7057# a_6775_n6668# VPWR sky130_fd_pr__pfet_01v8 ad=0.0504 pd=0.66 as=0.09835 ps=1.005 w=0.42 l=0.15
X190 a_10677_n6707# a_9693_n7057# a_10379_n6673# VPWR sky130_fd_pr__pfet_01v8 ad=0.1428 pd=1.225 as=0.2331 ps=1.395 w=0.84 l=0.15
X191 VPWR clk a_4515_n7057# VPWR sky130_fd_pr__pfet_01v8 ad=0.168 pd=1.42 as=0.3304 ps=2.83 w=1.12 l=0.15
X192 digital_layout1_0.sky130_fd_sc_hs__mux2i_1_5.Y counter.5 a_5276_n6247# VGND sky130_fd_pr__nfet_01v8_lvt ad=0.26085 pd=1.445 as=0.0888 ps=0.98 w=0.74 l=0.15
X193 a_8693_2320# a_8159_1931# a_8586_2360# VGND sky130_fd_pr__nfet_01v8_lvt ad=0.07875 pd=0.865 as=0.15563 ps=1.215 w=0.42 l=0.15
X194 a_5276_n6247# a_4964_n6247# VGND VGND sky130_fd_pr__nfet_01v8_lvt ad=0.0888 pd=0.98 as=0.1554 ps=1.16 w=0.74 l=0.15
X195 a_8126_n5953# digital_layout1_0.sky130_fd_sc_hs__nor2_1_0.A VPWR VPWR sky130_fd_pr__pfet_01v8 ad=0.1512 pd=1.39 as=0.3304 ps=2.83 w=1.12 l=0.15
X196 a_5605_2281# a_4621_1931# a_5307_2315# VPWR sky130_fd_pr__pfet_01v8 ad=0.1428 pd=1.225 as=0.2331 ps=1.395 w=0.84 l=0.15
X197 a_n238_n6628# digital_layout1_0.sky130_fd_sc_hs__dfxtp_1_2.D VPWR VPWR sky130_fd_pr__pfet_01v8 ad=0.09835 pd=1.005 as=0.2972 ps=2.41 w=0.42 l=0.15
X198 VGND reset_cycle digital_layout1_0.sky130_fd_sc_hs__nor3b_1_4.Y VGND sky130_fd_pr__nfet_01v8_lvt ad=0.1554 pd=1.16 as=0.1184 ps=1.06 w=0.74 l=0.15
X199 a_5499_n6707# a_4515_n7057# a_5201_n6673# VPWR sky130_fd_pr__pfet_01v8 ad=0.1428 pd=1.225 as=0.2331 ps=1.395 w=0.84 l=0.15
X200 VGND a_7225_n6707# a_7424_n6817# VGND sky130_fd_pr__nfet_01v8_lvt ad=0.1229 pd=1.085 as=0.1824 ps=1.85 w=0.64 l=0.15
X201 VPWR a_10539_2313# a_10494_2358# VPWR sky130_fd_pr__pfet_01v8 ad=0.18985 pd=1.545 as=0.0504 ps=0.66 w=0.42 l=0.15
X202 a_7462_1981# a_6321_1931# a_7305_2281# VGND sky130_fd_pr__nfet_01v8_lvt ad=0.05565 pd=0.685 as=0.1181 ps=1.035 w=0.42 l=0.15
X203 a_2516_n5953# reset_cycle a_2432_n5953# VPWR sky130_fd_pr__pfet_01v8 ad=0.2352 pd=1.54 as=0.1512 ps=1.39 w=1.12 l=0.15
X204 a_7007_2315# a_6855_2320# VGND VGND sky130_fd_pr__nfet_01v8_lvt ad=0.10905 pd=1.025 as=0.1648 ps=1.245 w=0.55 l=0.15
X205 digital_layout1_0.sky130_fd_sc_hs__nor3b_1_5.Y a_5645_n6209# VGND VGND sky130_fd_pr__nfet_01v8_lvt ad=0.2109 pd=2.05 as=0.1554 ps=1.16 w=0.74 l=0.15
X206 a_10227_n6668# a_9693_n7057# a_10120_n6628# VGND sky130_fd_pr__nfet_01v8_lvt ad=0.07875 pd=0.865 as=0.15563 ps=1.215 w=0.42 l=0.15
X207 a_3473_n6673# a_3321_n6668# VPWR VPWR sky130_fd_pr__pfet_01v8 ad=0.2331 pd=1.395 as=0.18985 ps=1.545 w=0.84 l=0.15
X208 a_8651_n6673# a_8499_n6668# VGND VGND sky130_fd_pr__nfet_01v8_lvt ad=0.10905 pd=1.025 as=0.1648 ps=1.245 w=0.55 l=0.15
X209 a_n1012_n5953# counter.1 VPWR VPWR sky130_fd_pr__pfet_01v8 ad=0.1512 pd=1.39 as=0.2177 ps=1.54 w=1.12 l=0.15
X210 digital_layout1_0.sky130_fd_sc_hs__nor3b_1_6.Y a_7367_n6209# VGND VGND sky130_fd_pr__nfet_01v8_lvt ad=0.2109 pd=2.05 as=0.1554 ps=1.16 w=0.74 l=0.15
X211 a_12229_2313# a_12077_2318# VPWR VPWR sky130_fd_pr__pfet_01v8 ad=0.2331 pd=1.395 as=0.18985 ps=1.545 w=0.84 l=0.15
X212 VPWR clk a_4621_1931# VPWR sky130_fd_pr__pfet_01v8 ad=0.168 pd=1.42 as=0.3304 ps=2.83 w=1.12 l=0.15
X213 VPWR clk a_6241_n7057# VPWR sky130_fd_pr__pfet_01v8 ad=0.168 pd=1.42 as=0.3304 ps=2.83 w=1.12 l=0.15
X214 VPWR a_n3133_n6707# a_n2934_n6817# VPWR sky130_fd_pr__pfet_01v8 ad=0.1862 pd=1.475 as=0.2478 ps=2.27 w=0.84 l=0.15
X215 a_245_2279# a_n560_2223# a_n53_2313# VGND sky130_fd_pr__nfet_01v8_lvt ad=0.1181 pd=1.035 as=0.10905 ps=1.025 w=0.55 l=0.15
X216 a_n486_n5953# digital_layout1_0.sky130_fd_sc_hs__nor2_1_0.A VPWR VPWR sky130_fd_pr__pfet_01v8 ad=0.1512 pd=1.39 as=0.3304 ps=2.83 w=1.12 l=0.15
X217 a_5049_n6668# a_4515_n7057# a_4942_n6628# VGND sky130_fd_pr__nfet_01v8_lvt ad=0.07875 pd=0.865 as=0.15563 ps=1.215 w=0.42 l=0.15
X218 a_8586_2360# sky130_fd_sc_hs__a211oi_1_7.Y VPWR VPWR sky130_fd_pr__pfet_01v8 ad=0.09835 pd=1.005 as=0.2972 ps=2.41 w=0.42 l=0.15
X219 VGND sky130_fd_sc_hs__mux2i_1_1.A1 a_n2893_1005# VGND sky130_fd_pr__nfet_01v8_lvt ad=0.15358 pd=1.2 as=0.2805 ps=2.12 w=0.55 l=0.15
X220 VPWR digital_layout1_0.sky130_fd_sc_hs__mux2i_1_0.S a_3353_n5953# VPWR sky130_fd_pr__pfet_01v8 ad=0.168 pd=1.42 as=0.3136 ps=2.8 w=1.12 l=0.15
X221 a_n1354_2363# a_n2266_2223# a_n1461_2279# VPWR sky130_fd_pr__pfet_01v8 ad=0.09975 pd=0.895 as=0.1428 ps=1.225 w=0.42 l=0.15
X222 a_10227_n6668# a_9872_n6763# a_10120_n6628# VPWR sky130_fd_pr__pfet_01v8 ad=0.09835 pd=1.005 as=0.09835 ps=1.005 w=0.42 l=0.15
X223 a_10271_n5953# rst VGND VGND sky130_fd_pr__nfet_01v8_lvt ad=0.13062 pd=1.025 as=0.2695 ps=2.08 w=0.55 l=0.15
X224 a_n3427_1958# a_n3952_2225# a_n3597_2320# VGND sky130_fd_pr__nfet_01v8_lvt ad=0.0441 pd=0.63 as=0.07875 ps=0.865 w=0.42 l=0.15
X225 a_7684_n5953# reset_cycle a_7600_n5953# VPWR sky130_fd_pr__pfet_01v8 ad=0.2352 pd=1.54 as=0.1512 ps=1.39 w=1.12 l=0.15
X226 a_2966_n6763# a_2787_n7057# VPWR VPWR sky130_fd_pr__pfet_01v8 ad=0.3304 pd=2.83 as=0.168 ps=1.42 w=1.12 l=0.15
X227 VPWR digital_layout1_0.sky130_fd_sc_hs__mux2i_1_0.S a_n1815_n5953# VPWR sky130_fd_pr__pfet_01v8 ad=0.168 pd=1.42 as=0.3136 ps=2.8 w=1.12 l=0.15
X228 a_n3147_2281# a_n3952_2225# a_n3445_2315# VGND sky130_fd_pr__nfet_01v8_lvt ad=0.1181 pd=1.035 as=0.10905 ps=1.025 w=0.55 l=0.15
X229 VGND a_5804_2171# a_5762_1981# VGND sky130_fd_pr__nfet_01v8_lvt ad=0.1197 pd=1.41 as=0.05565 ps=0.685 w=0.42 l=0.15
X230 reset_cycle a_10876_n6817# VGND VGND sky130_fd_pr__nfet_01v8_lvt ad=0.2109 pd=2.05 as=0.1229 ps=1.085 w=0.74 l=0.15
X231 a_12077_2318# a_11543_1929# a_11970_2358# VGND sky130_fd_pr__nfet_01v8_lvt ad=0.07875 pd=0.865 as=0.15563 ps=1.215 w=0.42 l=0.15
X232 VPWR a_3771_n6707# a_3970_n6817# VPWR sky130_fd_pr__pfet_01v8 ad=0.1862 pd=1.475 as=0.2478 ps=2.27 w=0.84 l=0.15
X233 a_12100_1025# digital_layout1_0.sky130_fd_sc_hs__inv_1_1.Y VPWR VPWR sky130_fd_pr__pfet_01v8 ad=0.231 pd=2.23 as=0.2394 ps=2.25 w=0.84 l=0.15
X234 VPWR a_7504_2171# a_7412_2365# VPWR sky130_fd_pr__pfet_01v8 ad=0.1239 pd=1.43 as=0.09975 ps=0.895 w=0.42 l=0.15
X235 a_6927_n6673# a_6775_n6668# VPWR VPWR sky130_fd_pr__pfet_01v8 ad=0.2331 pd=1.395 as=0.18985 ps=1.545 w=0.84 l=0.15
X236 a_8412_n6247# digital_layout1_0.sky130_fd_sc_hs__mux2i_1_0.S VGND VGND sky130_fd_pr__nfet_01v8_lvt ad=0.15675 pd=1.67 as=0.15675 ps=1.67 w=0.55 l=0.15
X237 VGND clk a_7965_n7057# VGND sky130_fd_pr__nfet_01v8_lvt ad=0.1739 pd=1.21 as=0.2109 ps=2.05 w=0.74 l=0.15
X238 VPWR a_7007_2315# a_6962_2360# VPWR sky130_fd_pr__pfet_01v8 ad=0.18985 pd=1.545 as=0.0504 ps=0.66 w=0.42 l=0.15
X239 digital_layout1_0.sky130_fd_sc_hs__nor3b_1_1.Y counter.1 VGND VGND sky130_fd_pr__nfet_01v8_lvt ad=0.1184 pd=1.06 as=0.13717 ps=1.13 w=0.74 l=0.15
X240 a_11722_2223# a_11543_1929# VGND VGND sky130_fd_pr__nfet_01v8_lvt ad=0.2553 pd=2.17 as=0.1739 ps=1.21 w=0.74 l=0.15
X241 VGND a_10876_n6817# a_10834_n7007# VGND sky130_fd_pr__nfet_01v8_lvt ad=0.1197 pd=1.41 as=0.05565 ps=0.685 w=0.42 l=0.15
X242 VPWR a_2246_n6817# a_2154_n6623# VPWR sky130_fd_pr__pfet_01v8 ad=0.1239 pd=1.43 as=0.09975 ps=0.895 w=0.42 l=0.15
X243 VGND a_n2934_n6817# a_n2976_n7007# VGND sky130_fd_pr__nfet_01v8_lvt ad=0.1197 pd=1.41 as=0.05565 ps=0.685 w=0.42 l=0.15
X244 digital_layout1_0.sky130_fd_sc_hs__nor3b_1_0.Y counter.0 VGND VGND sky130_fd_pr__nfet_01v8_lvt ad=0.1184 pd=1.06 as=0.13717 ps=1.13 w=0.74 l=0.15
X245 VGND digital_layout1_0.sky130_fd_sc_hs__nor3b_1_4.Y sky130_fd_sc_hs__a211oi_1_5.Y VGND sky130_fd_pr__nfet_01v8_lvt ad=0.1443 pd=1.13 as=0.1443 ps=1.13 w=0.74 l=0.15
X246 a_402_1979# a_n739_1929# a_245_2279# VGND sky130_fd_pr__nfet_01v8_lvt ad=0.05565 pd=0.685 as=0.1181 ps=1.035 w=0.42 l=0.15
X247 a_3434_2356# a_2793_1927# a_3327_2316# VPWR sky130_fd_pr__pfet_01v8 ad=0.0504 pd=0.66 as=0.09835 ps=1.005 w=0.42 l=0.15
X248 a_4800_2225# a_4621_1931# VPWR VPWR sky130_fd_pr__pfet_01v8 ad=0.3304 pd=2.83 as=0.168 ps=1.42 w=1.12 l=0.15
X249 a_3491_n7030# a_2966_n6763# a_3321_n6668# VGND sky130_fd_pr__nfet_01v8_lvt ad=0.0441 pd=0.63 as=0.07875 ps=0.865 w=0.42 l=0.15
X250 a_3777_2277# a_2972_2221# a_3479_2311# VGND sky130_fd_pr__nfet_01v8_lvt ad=0.1181 pd=1.035 as=0.10905 ps=1.025 w=0.55 l=0.15
X251 a_12412_1025# a_12100_1025# VGND VGND sky130_fd_pr__nfet_01v8_lvt ad=0.0888 pd=0.98 as=0.1554 ps=1.16 w=0.74 l=0.15
X252 VPWR a_8845_2315# a_8800_2360# VPWR sky130_fd_pr__pfet_01v8 ad=0.18985 pd=1.545 as=0.0504 ps=0.66 w=0.42 l=0.15
X253 a_12229_2313# a_12077_2318# VGND VGND sky130_fd_pr__nfet_01v8_lvt ad=0.10905 pd=1.025 as=0.1648 ps=1.245 w=0.55 l=0.15
X254 sky130_fd_sc_hs__a211oi_1_3.A1 sky130_fd_sc_hs__inv_1_2.A VGND VGND sky130_fd_pr__nfet_01v8_lvt ad=0.2109 pd=2.05 as=0.2627 ps=2.19 w=0.74 l=0.15
X255 VGND a_n1707_n6673# a_n1689_n7030# VGND sky130_fd_pr__nfet_01v8_lvt ad=0.1648 pd=1.245 as=0.0441 ps=0.63 w=0.42 l=0.15
X256 a_n928_n5953# reset_cycle a_n1012_n5953# VPWR sky130_fd_pr__pfet_01v8 ad=0.2352 pd=1.54 as=0.1512 ps=1.39 w=1.12 l=0.15
X257 digital_layout1_0.sky130_fd_sc_hs__dfxtp_1_2.Q a_518_n6817# VPWR VPWR sky130_fd_pr__pfet_01v8 ad=0.3304 pd=2.83 as=0.1862 ps=1.475 w=1.12 l=0.15
X258 digital_layout1_0.sky130_fd_sc_hs__mux2i_1_0.S a_n2893_1005# a_n2642_1261# VPWR sky130_fd_pr__pfet_01v8 ad=0.42 pd=2.99 as=0.1512 ps=1.39 w=1.12 l=0.15
X259 VGND a_7007_2315# a_7025_1958# VGND sky130_fd_pr__nfet_01v8_lvt ad=0.1648 pd=1.245 as=0.0441 ps=0.63 w=0.42 l=0.15
X260 digital_layout1_0.sky130_fd_sc_hs__dfxtp_1_5.Q a_5698_n6817# VPWR VPWR sky130_fd_pr__pfet_01v8 ad=0.3304 pd=2.83 as=0.1862 ps=1.475 w=1.12 l=0.15
X261 digital_layout1_0.sky130_fd_sc_hs__nor3b_1_7.Y a_9087_n6209# VGND VGND sky130_fd_pr__nfet_01v8_lvt ad=0.2109 pd=2.05 as=0.1554 ps=1.16 w=0.74 l=0.15
X262 VGND digital_layout1_0.sky130_fd_sc_hs__mux2i_1_6.Y digital_layout1_0.sky130_fd_sc_hs__dfxtp_1_6.D VGND sky130_fd_pr__nfet_01v8_lvt ad=0.2109 pd=2.05 as=0.1036 ps=1.02 w=0.74 l=0.15
X263 VGND a_2073_2277# a_2272_2167# VGND sky130_fd_pr__nfet_01v8_lvt ad=0.1229 pd=1.085 as=0.1824 ps=1.85 w=0.64 l=0.15
X264 a_3327_2316# a_2793_1927# a_3220_2356# VGND sky130_fd_pr__nfet_01v8_lvt ad=0.07875 pd=0.865 as=0.15563 ps=1.215 w=0.42 l=0.15
X265 digital_layout1_0.sky130_fd_sc_hs__dfxtp_1_5.D digital_layout1_0.sky130_fd_sc_hs__mux2i_1_5.Y a_4678_n5953# VPWR sky130_fd_pr__pfet_01v8 ad=0.3304 pd=2.83 as=0.1512 ps=1.39 w=1.12 l=0.15
X266 a_1809_n5953# a_1524_n6247# VPWR VPWR sky130_fd_pr__pfet_01v8 ad=0.308 pd=2.79 as=0.168 ps=1.42 w=1.12 l=0.15
X267 VPWR a_n2948_2171# a_n3040_2365# VPWR sky130_fd_pr__pfet_01v8 ad=0.1239 pd=1.43 as=0.09975 ps=0.895 w=0.42 l=0.15
X268 a_12211_1025# sky130_fd_sc_hs__mux2i_1_0.A1 sky130_fd_sc_hs__mux2i_1_0.Y VGND sky130_fd_pr__nfet_01v8_lvt ad=0.2109 pd=2.05 as=0.26085 ps=1.445 w=0.74 l=0.15
X269 a_2243_n1035# digital_layout1_0.sky130_fd_sc_hs__nand2b_1_0.Y VGND VGND sky130_fd_pr__nfet_01v8_lvt ad=0.0777 pd=0.95 as=0.1961 ps=2.01 w=0.74 l=0.15
X270 sky130_fd_sc_hs__inv_1_2.A a_2272_2167# VGND VGND sky130_fd_pr__nfet_01v8_lvt ad=0.2109 pd=2.05 as=0.1229 ps=1.085 w=0.74 l=0.15
X271 a_5605_2281# a_4800_2225# a_5307_2315# VGND sky130_fd_pr__nfet_01v8_lvt ad=0.1181 pd=1.035 as=0.10905 ps=1.025 w=0.55 l=0.15
X272 a_n3597_2320# a_n4131_1931# a_n3704_2360# VGND sky130_fd_pr__nfet_01v8_lvt ad=0.07875 pd=0.865 as=0.15563 ps=1.215 w=0.42 l=0.15
X273 a_3479_2311# a_3327_2316# VPWR VPWR sky130_fd_pr__pfet_01v8 ad=0.2331 pd=1.395 as=0.18985 ps=1.545 w=0.84 l=0.15
X274 digital_layout1_0.sky130_fd_sc_hs__dfxtp_1_3.Q a_2246_n6817# VPWR VPWR sky130_fd_pr__pfet_01v8 ad=0.3304 pd=2.83 as=0.1862 ps=1.475 w=1.12 l=0.15
X275 a_n3952_2225# a_n4131_1931# VPWR VPWR sky130_fd_pr__pfet_01v8 ad=0.3304 pd=2.83 as=0.168 ps=1.42 w=1.12 l=0.15
X276 a_n312_2358# sky130_fd_sc_hs__a211oi_1_1.Y VPWR VPWR sky130_fd_pr__pfet_01v8 ad=0.09835 pd=1.005 as=0.2972 ps=2.41 w=0.42 l=0.15
X277 VGND a_7424_n6817# a_7382_n7007# VGND sky130_fd_pr__nfet_01v8_lvt ad=0.1197 pd=1.41 as=0.05565 ps=0.685 w=0.42 l=0.15
X278 a_n205_2318# a_n560_2223# a_n312_2358# VPWR sky130_fd_pr__pfet_01v8 ad=0.09835 pd=1.005 as=0.09835 ps=1.005 w=0.42 l=0.15
X279 VGND a_3473_n6673# a_3491_n7030# VGND sky130_fd_pr__nfet_01v8_lvt ad=0.1648 pd=1.245 as=0.0441 ps=0.63 w=0.42 l=0.15
X280 a_8669_n7030# a_8144_n6763# a_8499_n6668# VGND sky130_fd_pr__nfet_01v8_lvt ad=0.0441 pd=0.63 as=0.07875 ps=0.865 w=0.42 l=0.15
X281 VGND a_n3133_n6707# a_n2934_n6817# VGND sky130_fd_pr__nfet_01v8_lvt ad=0.1229 pd=1.085 as=0.1824 ps=1.85 w=0.64 l=0.15
X282 sky130_fd_sc_hs__inv_1_3.A a_3976_2167# VPWR VPWR sky130_fd_pr__pfet_01v8 ad=0.3304 pd=2.83 as=0.1862 ps=1.475 w=1.12 l=0.15
X283 VPWR a_n1210_n6817# a_n1302_n6623# VPWR sky130_fd_pr__pfet_01v8 ad=0.1239 pd=1.43 as=0.09975 ps=0.895 w=0.42 l=0.15
X284 a_10360_n5953# rst a_10271_n5953# VPWR sky130_fd_pr__pfet_01v8 ad=0.1134 pd=1.11 as=0.2478 ps=2.27 w=0.84 l=0.15
X285 a_n3262_967# a_n3574_967# VGND VGND sky130_fd_pr__nfet_01v8_lvt ad=0.0888 pd=0.98 as=0.1554 ps=1.16 w=0.74 l=0.15
X286 a_221_n737# sky130_fd_sc_hs__a211oi_1_1.A1 VPWR VPWR sky130_fd_pr__pfet_01v8 ad=0.168 pd=1.42 as=0.2184 ps=1.51 w=1.12 l=0.15
X287 a_n3704_2360# sky130_fd_sc_hs__nor2_1_1.Y VGND VGND sky130_fd_pr__nfet_01v8_lvt ad=0.15563 pd=1.215 as=0.23015 ps=2.1 w=0.42 l=0.15
X288 VGND a_8845_2315# a_8863_1958# VGND sky130_fd_pr__nfet_01v8_lvt ad=0.1648 pd=1.245 as=0.0441 ps=0.63 w=0.42 l=0.15
X289 a_n1689_n7030# a_n2214_n6763# a_n1859_n6668# VGND sky130_fd_pr__nfet_01v8_lvt ad=0.0441 pd=0.63 as=0.07875 ps=0.865 w=0.42 l=0.15
X290 sky130_fd_sc_hs__a211oi_1_3.Y rst VGND VGND sky130_fd_pr__nfet_01v8_lvt ad=0.1961 pd=2.01 as=0.1443 ps=1.13 w=0.74 l=0.15
X291 a_n1813_n6247# digital_layout1_0.sky130_fd_sc_hs__dfxtp_1_1.Q digital_layout1_0.sky130_fd_sc_hs__mux2i_1_1.Y VGND sky130_fd_pr__nfet_01v8_lvt ad=0.2109 pd=2.05 as=0.26085 ps=1.445 w=0.74 l=0.15
X292 a_3497_1954# a_2972_2221# a_3327_2316# VGND sky130_fd_pr__nfet_01v8_lvt ad=0.0441 pd=0.63 as=0.07875 ps=0.865 w=0.42 l=0.15
X293 VGND reset_cycle digital_layout1_0.sky130_fd_sc_hs__nor3b_1_1.Y VGND sky130_fd_pr__nfet_01v8_lvt ad=0.1554 pd=1.16 as=0.1184 ps=1.06 w=0.74 l=0.15
X294 sky130_fd_sc_hs__mux2i_1_1.A0 a_n2948_2171# VPWR VPWR sky130_fd_pr__pfet_01v8 ad=0.3304 pd=2.83 as=0.1862 ps=1.475 w=1.12 l=0.15
X295 a_n331_n1033# digital_layout1_0.sky130_fd_sc_hs__nand2b_1_0.Y VGND VGND sky130_fd_pr__nfet_01v8_lvt ad=0.0777 pd=0.95 as=0.1961 ps=2.01 w=0.74 l=0.15
X296 VPWR a_10677_n6707# a_10876_n6817# VPWR sky130_fd_pr__pfet_01v8 ad=0.1862 pd=1.475 as=0.2478 ps=2.27 w=0.84 l=0.15
X297 a_3479_2311# a_3327_2316# VGND VGND sky130_fd_pr__nfet_01v8_lvt ad=0.10905 pd=1.025 as=0.1648 ps=1.245 w=0.55 l=0.15
X298 a_10494_2358# a_9853_1929# a_10387_2318# VPWR sky130_fd_pr__pfet_01v8 ad=0.0504 pd=0.66 as=0.09835 ps=1.005 w=0.42 l=0.15
X299 a_n3583_n6668# a_n3938_n6763# a_n3690_n6628# VPWR sky130_fd_pr__pfet_01v8 ad=0.09835 pd=1.005 as=0.09835 ps=1.005 w=0.42 l=0.15
X300 a_3220_2356# sky130_fd_sc_hs__a211oi_1_2.Y VPWR VPWR sky130_fd_pr__pfet_01v8 ad=0.09835 pd=1.005 as=0.2972 ps=2.41 w=0.42 l=0.15
X301 a_10387_2318# a_10032_2223# a_10280_2358# VPWR sky130_fd_pr__pfet_01v8 ad=0.09835 pd=1.005 as=0.09835 ps=1.005 w=0.42 l=0.15
X302 VPWR a_12726_2169# a_12634_2363# VPWR sky130_fd_pr__pfet_01v8 ad=0.1239 pd=1.43 as=0.09975 ps=0.895 w=0.42 l=0.15
X303 a_4694_n6763# a_4515_n7057# VPWR VPWR sky130_fd_pr__pfet_01v8 ad=0.3304 pd=2.83 as=0.168 ps=1.42 w=1.12 l=0.15
X304 a_1490_n6628# digital_layout1_0.sky130_fd_sc_hs__dfxtp_1_3.D VGND VGND sky130_fd_pr__nfet_01v8_lvt ad=0.15563 pd=1.215 as=0.23015 ps=2.1 w=0.42 l=0.15
X305 a_n2990_1981# a_n4131_1931# a_n3147_2281# VGND sky130_fd_pr__nfet_01v8_lvt ad=0.05565 pd=0.685 as=0.1181 ps=1.035 w=0.42 l=0.15
X306 sky130_fd_sc_hs__a211oi_1_5.Y rst a_2438_n741# VPWR sky130_fd_pr__pfet_01v8 ad=0.308 pd=2.79 as=0.1848 ps=1.45 w=1.12 l=0.15
X307 VGND clk a_6321_1931# VGND sky130_fd_pr__nfet_01v8_lvt ad=0.1739 pd=1.21 as=0.2109 ps=2.05 w=0.74 l=0.15
X308 VGND digital_layout1_0.sky130_fd_sc_hs__nor3b_1_6.Y sky130_fd_sc_hs__a211oi_1_7.Y VGND sky130_fd_pr__nfet_01v8_lvt ad=0.1443 pd=1.13 as=0.1443 ps=1.13 w=0.74 l=0.15
X309 a_2154_n6623# a_1242_n6763# a_2047_n6707# VPWR sky130_fd_pr__pfet_01v8 ad=0.09975 pd=0.895 as=0.1428 ps=1.225 w=0.42 l=0.15
X310 sky130_fd_sc_hs__a211oi_1_4.Y rst a_3068_n739# VPWR sky130_fd_pr__pfet_01v8 ad=0.308 pd=2.79 as=0.1848 ps=1.45 w=1.12 l=0.15
X311 a_2432_n5953# counter.3 VPWR VPWR sky130_fd_pr__pfet_01v8 ad=0.1512 pd=1.39 as=0.2177 ps=1.54 w=1.12 l=0.15
X312 sky130_fd_sc_hs__inv_1_4.A a_5804_2171# VPWR VPWR sky130_fd_pr__pfet_01v8 ad=0.3304 pd=2.83 as=0.1862 ps=1.475 w=1.12 l=0.15
X313 sky130_fd_sc_hs__a211oi_1_3.Y rst a_1150_n741# VPWR sky130_fd_pr__pfet_01v8 ad=0.308 pd=2.79 as=0.1848 ps=1.45 w=1.12 l=0.15
X314 a_n3938_n6763# a_n4117_n7057# VPWR VPWR sky130_fd_pr__pfet_01v8 ad=0.3304 pd=2.83 as=0.168 ps=1.42 w=1.12 l=0.15
X315 digital_layout1_0.sky130_fd_sc_hs__nor3b_1_3.Y counter.3 VGND VGND sky130_fd_pr__nfet_01v8_lvt ad=0.1184 pd=1.06 as=0.13717 ps=1.13 w=0.74 l=0.15
X316 sky130_fd_sc_hs__a211oi_1_6.Y rst a_4418_n737# VPWR sky130_fd_pr__pfet_01v8 ad=0.308 pd=2.79 as=0.1848 ps=1.45 w=1.12 l=0.15
X317 a_8392_n6628# digital_layout1_0.sky130_fd_sc_hs__dfxtp_1_7.D VPWR VPWR sky130_fd_pr__pfet_01v8 ad=0.09835 pd=1.005 as=0.2972 ps=2.41 w=0.42 l=0.15
X318 a_3355_n6247# digital_layout1_0.sky130_fd_sc_hs__dfxtp_1_4.Q digital_layout1_0.sky130_fd_sc_hs__mux2i_1_4.Y VGND sky130_fd_pr__nfet_01v8_lvt ad=0.2109 pd=2.05 as=0.26085 ps=1.445 w=0.74 l=0.15
X319 a_4678_n5953# digital_layout1_0.sky130_fd_sc_hs__nor2_1_0.A VPWR VPWR sky130_fd_pr__pfet_01v8 ad=0.1512 pd=1.39 as=0.3304 ps=2.83 w=1.12 l=0.15
X320 VGND a_7305_2281# a_7504_2171# VGND sky130_fd_pr__nfet_01v8_lvt ad=0.1229 pd=1.085 as=0.1824 ps=1.85 w=0.64 l=0.15
X321 VPWR digital_layout1_0.sky130_fd_sc_hs__nand2b_1_0.Y a_221_n737# VPWR sky130_fd_pr__pfet_01v8 ad=0.2184 pd=1.51 as=0.308 ps=2.79 w=1.12 l=0.15
X322 a_2873_n1033# digital_layout1_0.sky130_fd_sc_hs__nand2b_1_0.Y VGND VGND sky130_fd_pr__nfet_01v8_lvt ad=0.0777 pd=0.95 as=0.1961 ps=2.01 w=0.74 l=0.15
X323 VPWR a_9148_n6817# a_9056_n6623# VPWR sky130_fd_pr__pfet_01v8 ad=0.1239 pd=1.43 as=0.09975 ps=0.895 w=0.42 l=0.15
X324 digital_layout1_0.sky130_fd_sc_hs__mux2i_1_4.Y counter.4 a_3353_n5953# VPWR sky130_fd_pr__pfet_01v8 ad=0.168 pd=1.42 as=0.3136 ps=2.8 w=1.12 l=0.15
X325 VGND digital_layout1_0.sky130_fd_sc_hs__nor3b_1_7.Y sky130_fd_sc_hs__a211oi_1_6.Y VGND sky130_fd_pr__nfet_01v8_lvt ad=0.1443 pd=1.13 as=0.1443 ps=1.13 w=0.74 l=0.15
X326 digital_layout1_0.sky130_fd_sc_hs__mux2i_1_3.Y counter.3 a_1836_n6247# VGND sky130_fd_pr__nfet_01v8_lvt ad=0.26085 pd=1.445 as=0.0888 ps=0.98 w=0.74 l=0.15
X327 digital_layout1_0.sky130_fd_sc_hs__dfxtp_1_1.D digital_layout1_0.sky130_fd_sc_hs__nor2_1_0.A VGND VGND sky130_fd_pr__nfet_01v8_lvt ad=0.1036 pd=1.02 as=0.2109 ps=2.05 w=0.74 l=0.15
X328 a_10334_n6628# a_9693_n7057# a_10227_n6668# VPWR sky130_fd_pr__pfet_01v8 ad=0.0504 pd=0.66 as=0.09835 ps=1.005 w=0.42 l=0.15
X329 a_9106_n7007# a_7965_n7057# a_8949_n6707# VGND sky130_fd_pr__nfet_01v8_lvt ad=0.05565 pd=0.685 as=0.1181 ps=1.035 w=0.42 l=0.15
X330 digital_layout1_0.sky130_fd_sc_hs__dfxtp_1_3.D digital_layout1_0.sky130_fd_sc_hs__mux2i_1_3.Y a_1238_n5953# VPWR sky130_fd_pr__pfet_01v8 ad=0.3304 pd=2.83 as=0.1512 ps=1.39 w=1.12 l=0.15
X331 sky130_fd_sc_hs__inv_1_5.A a_7504_2171# VGND VGND sky130_fd_pr__nfet_01v8_lvt ad=0.2109 pd=2.05 as=0.1229 ps=1.085 w=0.74 l=0.15
X332 VPWR a_5201_n6673# a_5156_n6628# VPWR sky130_fd_pr__pfet_01v8 ad=0.18985 pd=1.545 as=0.0504 ps=0.66 w=0.42 l=0.15
X333 a_10539_2313# a_10387_2318# VPWR VPWR sky130_fd_pr__pfet_01v8 ad=0.2331 pd=1.395 as=0.18985 ps=1.545 w=0.84 l=0.15
X334 a_n1639_n5953# digital_layout1_0.sky130_fd_sc_hs__dfxtp_1_1.Q digital_layout1_0.sky130_fd_sc_hs__mux2i_1_1.Y VPWR sky130_fd_pr__pfet_01v8 ad=0.3192 pd=2.81 as=0.168 ps=1.42 w=1.12 l=0.15
X335 a_6775_n6668# a_6241_n7057# a_6668_n6628# VGND sky130_fd_pr__nfet_01v8_lvt ad=0.07875 pd=0.865 as=0.15563 ps=1.215 w=0.42 l=0.15
X336 a_5156_n6628# a_4515_n7057# a_5049_n6668# VPWR sky130_fd_pr__pfet_01v8 ad=0.0504 pd=0.66 as=0.09835 ps=1.005 w=0.42 l=0.15
X337 VPWR digital_layout1_0.sky130_fd_sc_hs__mux2i_1_0.S a_6797_n5953# VPWR sky130_fd_pr__pfet_01v8 ad=0.168 pd=1.42 as=0.3136 ps=2.8 w=1.12 l=0.15
X338 VGND digital_layout1_0.sky130_fd_sc_hs__mux2i_1_2.Y digital_layout1_0.sky130_fd_sc_hs__dfxtp_1_2.D VGND sky130_fd_pr__nfet_01v8_lvt ad=0.2109 pd=2.05 as=0.1036 ps=1.02 w=0.74 l=0.15
X339 VGND a_12229_2313# a_12247_1956# VGND sky130_fd_pr__nfet_01v8_lvt ad=0.1648 pd=1.245 as=0.0441 ps=0.63 w=0.42 l=0.15
X340 a_n3463_967# sky130_fd_sc_hs__mux2i_1_1.A1 sky130_fd_sc_hs__mux2i_1_1.Y VGND sky130_fd_pr__nfet_01v8_lvt ad=0.2109 pd=2.05 as=0.26085 ps=1.445 w=0.74 l=0.15
X341 a_504_n737# digital_layout1_0.sky130_fd_sc_hs__nor3b_1_1.Y a_221_n737# VPWR sky130_fd_pr__pfet_01v8 ad=0.1848 pd=1.45 as=0.168 ps=1.42 w=1.12 l=0.15
X342 a_n3690_n6628# digital_layout1_0.sky130_fd_sc_hs__dfxtp_1_0.D VPWR VPWR sky130_fd_pr__pfet_01v8 ad=0.09835 pd=1.005 as=0.2972 ps=2.41 w=0.42 l=0.15
X343 sky130_fd_sc_hs__nor2_1_1.Y sky130_fd_sc_hs__mux2i_1_1.Y a_n3860_1261# VPWR sky130_fd_pr__pfet_01v8 ad=0.3304 pd=2.83 as=0.1512 ps=1.39 w=1.12 l=0.15
X344 sky130_fd_sc_hs__nor2_1_0.Y rst VGND VGND sky130_fd_pr__nfet_01v8_lvt ad=0.1036 pd=1.02 as=0.2109 ps=2.05 w=0.74 l=0.15
X345 VGND digital_layout1_0.sky130_fd_sc_hs__mux2i_1_0.S a_6799_n6247# VGND sky130_fd_pr__nfet_01v8_lvt ad=0.1554 pd=1.16 as=0.2109 ps=2.05 w=0.74 l=0.15
X346 a_8523_n6247# digital_layout1_0.sky130_fd_sc_hs__dfxtp_1_7.Q digital_layout1_0.sky130_fd_sc_hs__mux2i_1_7.Y VGND sky130_fd_pr__nfet_01v8_lvt ad=0.2109 pd=2.05 as=0.26085 ps=1.445 w=0.74 l=0.15
X347 a_n312_2358# sky130_fd_sc_hs__a211oi_1_1.Y VGND VGND sky130_fd_pr__nfet_01v8_lvt ad=0.15563 pd=1.215 as=0.23015 ps=2.1 w=0.42 l=0.15
X348 digital_layout1_0.sky130_fd_sc_hs__mux2i_1_0.S sky130_fd_sc_hs__mux2i_1_1.A0 VGND VGND sky130_fd_pr__nfet_01v8_lvt ad=0.13135 pd=1.095 as=0.15358 ps=1.2 w=0.74 l=0.15
X349 sky130_fd_sc_hs__a211oi_1_1.Y rst VGND VGND sky130_fd_pr__nfet_01v8_lvt ad=0.1961 pd=2.01 as=0.1443 ps=1.13 w=0.74 l=0.15
X350 VGND a_319_n6707# a_518_n6817# VGND sky130_fd_pr__nfet_01v8_lvt ad=0.1229 pd=1.085 as=0.1824 ps=1.85 w=0.64 l=0.15
X351 VPWR clk a_n4117_n7057# VPWR sky130_fd_pr__pfet_01v8 ad=0.168 pd=1.42 as=0.3304 ps=2.83 w=1.12 l=0.15
X352 VPWR a_1749_n6673# a_1704_n6628# VPWR sky130_fd_pr__pfet_01v8 ad=0.18985 pd=1.545 as=0.0504 ps=0.66 w=0.42 l=0.15
X353 a_n486_n6763# a_n665_n7057# VGND VGND sky130_fd_pr__nfet_01v8_lvt ad=0.2553 pd=2.17 as=0.1739 ps=1.21 w=0.74 l=0.15
X354 VGND reset_cycle a_9755_n6209# VGND sky130_fd_pr__nfet_01v8_lvt ad=0.22412 pd=1.365 as=0.15675 ps=1.67 w=0.55 l=0.15
X355 digital_layout1_0.sky130_fd_sc_hs__mux2i_1_7.Y counter.7 a_8521_n5953# VPWR sky130_fd_pr__pfet_01v8 ad=0.168 pd=1.42 as=0.3136 ps=2.8 w=1.12 l=0.15
X356 sky130_fd_sc_hs__a211oi_1_4.Y sky130_fd_sc_hs__a211oi_1_4.A1 a_2873_n1033# VGND sky130_fd_pr__nfet_01v8_lvt ad=0.1443 pd=1.13 as=0.0777 ps=0.95 w=0.74 l=0.15
X357 a_6775_n6668# a_6420_n6763# a_6668_n6628# VPWR sky130_fd_pr__pfet_01v8 ad=0.09835 pd=1.005 as=0.09835 ps=1.005 w=0.42 l=0.15
X358 a_1704_n6628# a_1063_n7057# a_1597_n6668# VPWR sky130_fd_pr__pfet_01v8 ad=0.0504 pd=0.66 as=0.09835 ps=1.005 w=0.42 l=0.15
X359 VPWR a_3479_2311# a_3434_2356# VPWR sky130_fd_pr__pfet_01v8 ad=0.18985 pd=1.545 as=0.0504 ps=0.66 w=0.42 l=0.15
X360 a_5048_2360# sky130_fd_sc_hs__a211oi_1_5.Y VPWR VPWR sky130_fd_pr__pfet_01v8 ad=0.09835 pd=1.005 as=0.2972 ps=2.41 w=0.42 l=0.15
X361 digital_layout1_0.sky130_fd_sc_hs__dfxtp_1_5.D digital_layout1_0.sky130_fd_sc_hs__nor2_1_0.A VGND VGND sky130_fd_pr__nfet_01v8_lvt ad=0.1036 pd=1.02 as=0.2109 ps=2.05 w=0.74 l=0.15
X362 a_10387_2318# a_9853_1929# a_10280_2358# VGND sky130_fd_pr__nfet_01v8_lvt ad=0.07875 pd=0.865 as=0.15563 ps=1.215 w=0.42 l=0.15
X363 sky130_fd_sc_hs__a211oi_1_5.A1 sky130_fd_sc_hs__inv_1_4.A VGND VGND sky130_fd_pr__nfet_01v8_lvt ad=0.2109 pd=2.05 as=0.2627 ps=2.19 w=0.74 l=0.15
X364 digital_layout1_0.sky130_fd_sc_hs__dfxtp_1_6.Q a_7424_n6817# VGND VGND sky130_fd_pr__nfet_01v8_lvt ad=0.2109 pd=2.05 as=0.1229 ps=1.085 w=0.74 l=0.15
X365 VGND a_2047_n6707# a_2246_n6817# VGND sky130_fd_pr__nfet_01v8_lvt ad=0.1229 pd=1.085 as=0.1824 ps=1.85 w=0.64 l=0.15
X366 VGND a_n2948_2171# a_n2990_1981# VGND sky130_fd_pr__nfet_01v8_lvt ad=0.1197 pd=1.41 as=0.05565 ps=0.685 w=0.42 l=0.15
X367 VGND a_9342_2171# a_9300_1981# VGND sky130_fd_pr__nfet_01v8_lvt ad=0.1197 pd=1.41 as=0.05565 ps=0.685 w=0.42 l=0.15
X368 digital_layout1_0.sky130_fd_sc_hs__dfxtp_1_0.D digital_layout1_0.sky130_fd_sc_hs__nor2_1_0.A VGND VGND sky130_fd_pr__nfet_01v8_lvt ad=0.1036 pd=1.02 as=0.2109 ps=2.05 w=0.74 l=0.15
X369 VPWR a_9143_2281# a_9342_2171# VPWR sky130_fd_pr__pfet_01v8 ad=0.1862 pd=1.475 as=0.2478 ps=2.27 w=0.84 l=0.15
X370 a_10677_n6707# a_9872_n6763# a_10379_n6673# VGND sky130_fd_pr__nfet_01v8_lvt ad=0.1181 pd=1.035 as=0.10905 ps=1.025 w=0.55 l=0.15
X371 a_1497_n741# sky130_fd_sc_hs__a211oi_1_2.A1 VPWR VPWR sky130_fd_pr__pfet_01v8 ad=0.168 pd=1.42 as=0.2184 ps=1.51 w=1.12 l=0.15
X372 VGND a_5201_n6673# a_5219_n7030# VGND sky130_fd_pr__nfet_01v8_lvt ad=0.1648 pd=1.245 as=0.0441 ps=0.63 w=0.42 l=0.15
X373 VGND sky130_fd_sc_hs__mux2i_1_0.A1 a_12779_1063# VGND sky130_fd_pr__nfet_01v8_lvt ad=0.15358 pd=1.2 as=0.2805 ps=2.12 w=0.55 l=0.15
X374 a_4964_n6247# digital_layout1_0.sky130_fd_sc_hs__mux2i_1_0.S VGND VGND sky130_fd_pr__nfet_01v8_lvt ad=0.15675 pd=1.67 as=0.15675 ps=1.67 w=0.55 l=0.15
X375 a_3473_n6673# a_3321_n6668# VGND VGND sky130_fd_pr__nfet_01v8_lvt ad=0.10905 pd=1.025 as=0.1648 ps=1.245 w=0.55 l=0.15
X376 VGND a_245_2279# a_444_2169# VGND sky130_fd_pr__nfet_01v8_lvt ad=0.1229 pd=1.085 as=0.1824 ps=1.85 w=0.64 l=0.15
X377 a_10837_2279# a_9853_1929# a_10539_2313# VPWR sky130_fd_pr__pfet_01v8 ad=0.1428 pd=1.225 as=0.2331 ps=1.395 w=0.84 l=0.15
X378 sky130_fd_sc_hs__a211oi_1_1.A1 sky130_fd_sc_hs__inv_1_1.A VPWR VPWR sky130_fd_pr__pfet_01v8 ad=0.3304 pd=2.83 as=0.3864 ps=2.93 w=1.12 l=0.15
X379 VGND digital_layout1_0.sky130_fd_sc_hs__mux2i_1_0.S a_9087_n6209# VGND sky130_fd_pr__nfet_01v8_lvt ad=0.13717 pd=1.13 as=0.2695 ps=2.08 w=0.55 l=0.15
X380 a_5499_n6707# a_4694_n6763# a_5201_n6673# VGND sky130_fd_pr__nfet_01v8_lvt ad=0.1181 pd=1.035 as=0.10905 ps=1.025 w=0.55 l=0.15
X381 a_1268_2221# a_1089_1927# VGND VGND sky130_fd_pr__nfet_01v8_lvt ad=0.2553 pd=2.17 as=0.1739 ps=1.21 w=0.74 l=0.15
X382 VPWR clk a_1063_n7057# VPWR sky130_fd_pr__pfet_01v8 ad=0.168 pd=1.42 as=0.3304 ps=2.83 w=1.12 l=0.15
X383 a_2073_2277# a_1089_1927# a_1775_2311# VPWR sky130_fd_pr__pfet_01v8 ad=0.1428 pd=1.225 as=0.2331 ps=1.395 w=0.84 l=0.15
X384 a_7007_2315# a_6855_2320# VPWR VPWR sky130_fd_pr__pfet_01v8 ad=0.2331 pd=1.395 as=0.18985 ps=1.545 w=0.84 l=0.15
X385 VGND digital_layout1_0.sky130_fd_sc_hs__mux2i_1_0.S a_n1245_n6209# VGND sky130_fd_pr__nfet_01v8_lvt ad=0.13717 pd=1.13 as=0.2695 ps=2.08 w=0.55 l=0.15
X386 sky130_fd_sc_hs__inv_1_1.A a_444_2169# VGND VGND sky130_fd_pr__nfet_01v8_lvt ad=0.2109 pd=2.05 as=0.1229 ps=1.085 w=0.74 l=0.15
X387 digital_layout1_0.sky130_fd_sc_hs__mux2i_1_5.Y counter.5 a_5073_n5953# VPWR sky130_fd_pr__pfet_01v8 ad=0.168 pd=1.42 as=0.3136 ps=2.8 w=1.12 l=0.15
X388 VGND a_n53_2313# a_n35_1956# VGND sky130_fd_pr__nfet_01v8_lvt ad=0.1648 pd=1.245 as=0.0441 ps=0.63 w=0.42 l=0.15
X389 a_10539_2313# a_10387_2318# VGND VGND sky130_fd_pr__nfet_01v8_lvt ad=0.10905 pd=1.025 as=0.1648 ps=1.245 w=0.55 l=0.15
X390 digital_layout1_0.sky130_fd_sc_hs__mux2i_1_4.Y counter.4 a_3556_n6247# VGND sky130_fd_pr__nfet_01v8_lvt ad=0.26085 pd=1.445 as=0.0888 ps=0.98 w=0.74 l=0.15
X391 digital_layout1_0.sky130_fd_sc_hs__dfxtp_1_4.D digital_layout1_0.sky130_fd_sc_hs__mux2i_1_4.Y a_2958_n5953# VPWR sky130_fd_pr__pfet_01v8 ad=0.3304 pd=2.83 as=0.1512 ps=1.39 w=1.12 l=0.15
X392 VPWR digital_layout1_0.sky130_fd_sc_hs__nand2b_1_0.Y a_1497_n741# VPWR sky130_fd_pr__pfet_01v8 ad=0.2184 pd=1.51 as=0.308 ps=2.79 w=1.12 l=0.15
X393 a_2047_n6707# a_1063_n7057# a_1749_n6673# VPWR sky130_fd_pr__pfet_01v8 ad=0.1428 pd=1.225 as=0.2331 ps=1.395 w=0.84 l=0.15
X394 a_21_n6673# a_n131_n6668# VPWR VPWR sky130_fd_pr__pfet_01v8 ad=0.2331 pd=1.395 as=0.18985 ps=1.545 w=0.84 l=0.15
X395 digital_layout1_0.sky130_fd_sc_hs__nor3b_1_7.Y a_9087_n6209# a_9404_n5953# VPWR sky130_fd_pr__pfet_01v8 ad=0.3304 pd=2.83 as=0.2352 ps=1.54 w=1.12 l=0.15
X396 a_3556_n6247# a_3244_n6247# VGND VGND sky130_fd_pr__nfet_01v8_lvt ad=0.0888 pd=0.98 as=0.1554 ps=1.16 w=0.74 l=0.15
X397 a_n3690_n6628# digital_layout1_0.sky130_fd_sc_hs__dfxtp_1_0.D VGND VGND sky130_fd_pr__nfet_01v8_lvt ad=0.15563 pd=1.215 as=0.23015 ps=2.1 w=0.42 l=0.15
X398 digital_layout1_0.sky130_fd_sc_hs__nor3b_1_5.Y a_5645_n6209# a_5962_n5953# VPWR sky130_fd_pr__pfet_01v8 ad=0.3304 pd=2.83 as=0.2352 ps=1.54 w=1.12 l=0.15
X399 a_n3133_n6707# a_n3938_n6763# a_n3431_n6673# VGND sky130_fd_pr__nfet_01v8_lvt ad=0.1181 pd=1.035 as=0.10905 ps=1.025 w=0.55 l=0.15
X400 a_13030_1319# sky130_fd_sc_hs__mux2i_1_0.A0 VPWR VPWR sky130_fd_pr__pfet_01v8 ad=0.1512 pd=1.39 as=0.2345 ps=1.58 w=1.12 l=0.15
X401 a_n1924_n6247# digital_layout1_0.sky130_fd_sc_hs__mux2i_1_0.S VGND VGND sky130_fd_pr__nfet_01v8_lvt ad=0.15675 pd=1.67 as=0.15675 ps=1.67 w=0.55 l=0.15
X402 a_12634_2363# a_11722_2223# a_12527_2279# VPWR sky130_fd_pr__pfet_01v8 ad=0.09975 pd=0.895 as=0.1428 ps=1.225 w=0.42 l=0.15
X403 VGND sky130_fd_sc_hs__mux2i_1_0.Y sky130_fd_sc_hs__nor2_1_0.Y VGND sky130_fd_pr__nfet_01v8_lvt ad=0.2109 pd=2.05 as=0.1036 ps=1.02 w=0.74 l=0.15
X404 VPWR digital_layout1_0.sky130_fd_sc_hs__nand2b_1_0.Y a_2785_n739# VPWR sky130_fd_pr__pfet_01v8 ad=0.2184 pd=1.51 as=0.308 ps=2.79 w=1.12 l=0.15
X405 VPWR sky130_fd_sc_hs__mux2i_1_0.A1 a_12779_1063# VPWR sky130_fd_pr__pfet_01v8 ad=0.2345 pd=1.58 as=0.2478 ps=2.27 w=0.84 l=0.15
X406 a_7225_n6707# a_6420_n6763# a_6927_n6673# VGND sky130_fd_pr__nfet_01v8_lvt ad=0.1181 pd=1.035 as=0.10905 ps=1.025 w=0.55 l=0.15
X407 VPWR a_n1707_n6673# a_n1752_n6628# VPWR sky130_fd_pr__pfet_01v8 ad=0.18985 pd=1.545 as=0.0504 ps=0.66 w=0.42 l=0.15
X408 a_1780_n741# digital_layout1_0.sky130_fd_sc_hs__nor3b_1_3.Y a_1497_n741# VPWR sky130_fd_pr__pfet_01v8 ad=0.1848 pd=1.45 as=0.168 ps=1.42 w=1.12 l=0.15
X409 a_n2734_n5953# counter.0 VPWR VPWR sky130_fd_pr__pfet_01v8 ad=0.1512 pd=1.39 as=0.2177 ps=1.54 w=1.12 l=0.15
X410 VGND a_3479_2311# a_3497_1954# VGND sky130_fd_pr__nfet_01v8_lvt ad=0.1648 pd=1.245 as=0.0441 ps=0.63 w=0.42 l=0.15
X411 VGND a_6927_n6673# a_6945_n7030# VGND sky130_fd_pr__nfet_01v8_lvt ad=0.1648 pd=1.245 as=0.0441 ps=0.63 w=0.42 l=0.15
X412 VGND clk a_9693_n7057# VGND sky130_fd_pr__nfet_01v8_lvt ad=0.1739 pd=1.21 as=0.2109 ps=2.05 w=0.74 l=0.15
X413 a_n1409_n6707# a_n2393_n7057# a_n1707_n6673# VPWR sky130_fd_pr__pfet_01v8 ad=0.1428 pd=1.225 as=0.2331 ps=1.395 w=0.84 l=0.15
X414 a_9143_2281# a_8338_2225# a_8845_2315# VGND sky130_fd_pr__nfet_01v8_lvt ad=0.1181 pd=1.035 as=0.10905 ps=1.025 w=0.55 l=0.15
X415 VGND clk a_9853_1929# VGND sky130_fd_pr__nfet_01v8_lvt ad=0.1739 pd=1.21 as=0.2109 ps=2.05 w=0.74 l=0.15
X416 digital_layout1_0.sky130_fd_sc_hs__dfxtp_1_1.Q a_n1210_n6817# VGND VGND sky130_fd_pr__nfet_01v8_lvt ad=0.2109 pd=2.05 as=0.1229 ps=1.085 w=0.74 l=0.15
X417 VGND clk a_2793_1927# VGND sky130_fd_pr__nfet_01v8_lvt ad=0.1739 pd=1.21 as=0.2109 ps=2.05 w=0.74 l=0.15
X418 a_11970_2358# sky130_fd_sc_hs__nor2_1_0.Y VGND VGND sky130_fd_pr__nfet_01v8_lvt ad=0.15563 pd=1.215 as=0.23015 ps=2.1 w=0.42 l=0.15
X419 a_1524_n6247# digital_layout1_0.sky130_fd_sc_hs__mux2i_1_0.S VGND VGND sky130_fd_pr__nfet_01v8_lvt ad=0.15675 pd=1.67 as=0.15675 ps=1.67 w=0.55 l=0.15
X420 a_6500_2225# a_6321_1931# VGND VGND sky130_fd_pr__nfet_01v8_lvt ad=0.2553 pd=2.17 as=0.1739 ps=1.21 w=0.74 l=0.15
X421 sky130_fd_sc_hs__mux2i_1_0.A0 a_12726_2169# VGND VGND sky130_fd_pr__nfet_01v8_lvt ad=0.2109 pd=2.05 as=0.1229 ps=1.085 w=0.74 l=0.15
X422 a_1585_n1035# digital_layout1_0.sky130_fd_sc_hs__nand2b_1_0.Y VGND VGND sky130_fd_pr__nfet_01v8_lvt ad=0.0777 pd=0.95 as=0.1961 ps=2.01 w=0.74 l=0.15
X423 a_8144_n6763# a_7965_n7057# VGND VGND sky130_fd_pr__nfet_01v8_lvt ad=0.2553 pd=2.17 as=0.1739 ps=1.21 w=0.74 l=0.15
X424 a_4154_n5953# counter.4 VPWR VPWR sky130_fd_pr__pfet_01v8 ad=0.1512 pd=1.39 as=0.2177 ps=1.54 w=1.12 l=0.15
X425 digital_layout1_0.sky130_fd_sc_hs__dfxtp_1_7.D digital_layout1_0.sky130_fd_sc_hs__nor2_1_0.A VGND VGND sky130_fd_pr__nfet_01v8_lvt ad=0.1036 pd=1.02 as=0.2109 ps=2.05 w=0.74 l=0.15
X426 digital_layout1_0.sky130_fd_sc_hs__nor3b_1_4.Y counter.4 VGND VGND sky130_fd_pr__nfet_01v8_lvt ad=0.1184 pd=1.06 as=0.13717 ps=1.13 w=0.74 l=0.15
X427 a_n1461_2279# a_n2445_1929# a_n1759_2313# VPWR sky130_fd_pr__pfet_01v8 ad=0.1428 pd=1.225 as=0.2331 ps=1.395 w=0.84 l=0.15
X428 a_n1966_n6628# digital_layout1_0.sky130_fd_sc_hs__dfxtp_1_1.D VPWR VPWR sky130_fd_pr__pfet_01v8 ad=0.09835 pd=1.005 as=0.2972 ps=2.41 w=0.42 l=0.15
X429 VPWR a_n3445_2315# a_n3490_2360# VPWR sky130_fd_pr__pfet_01v8 ad=0.18985 pd=1.545 as=0.0504 ps=0.66 w=0.42 l=0.15
X430 a_1635_n6247# digital_layout1_0.sky130_fd_sc_hs__dfxtp_1_3.Q digital_layout1_0.sky130_fd_sc_hs__mux2i_1_3.Y VGND sky130_fd_pr__nfet_01v8_lvt ad=0.2109 pd=2.05 as=0.26085 ps=1.445 w=0.74 l=0.15
X431 a_n200_n6247# digital_layout1_0.sky130_fd_sc_hs__mux2i_1_0.S VPWR VPWR sky130_fd_pr__pfet_01v8 ad=0.231 pd=2.23 as=0.2394 ps=2.25 w=0.84 l=0.15
X432 VPWR clk a_1089_1927# VPWR sky130_fd_pr__pfet_01v8 ad=0.168 pd=1.42 as=0.3304 ps=2.83 w=1.12 l=0.15
X433 VPWR a_2272_2167# a_2180_2361# VPWR sky130_fd_pr__pfet_01v8 ad=0.1239 pd=1.43 as=0.09975 ps=0.895 w=0.42 l=0.15
X434 a_n486_n6763# a_n665_n7057# VPWR VPWR sky130_fd_pr__pfet_01v8 ad=0.3304 pd=2.83 as=0.168 ps=1.42 w=1.12 l=0.15
X435 a_2155_n741# sky130_fd_sc_hs__a211oi_1_5.A1 VPWR VPWR sky130_fd_pr__pfet_01v8 ad=0.168 pd=1.42 as=0.2184 ps=1.51 w=1.12 l=0.15
X436 VGND a_5499_n6707# a_5698_n6817# VGND sky130_fd_pr__nfet_01v8_lvt ad=0.1229 pd=1.085 as=0.1824 ps=1.85 w=0.64 l=0.15
X437 VGND a_518_n6817# a_476_n7007# VGND sky130_fd_pr__nfet_01v8_lvt ad=0.1197 pd=1.41 as=0.05565 ps=0.685 w=0.42 l=0.15
X438 a_6688_n6247# digital_layout1_0.sky130_fd_sc_hs__mux2i_1_0.S VPWR VPWR sky130_fd_pr__pfet_01v8 ad=0.231 pd=2.23 as=0.2394 ps=2.25 w=0.84 l=0.15
X439 VGND a_n2893_1005# digital_layout1_0.sky130_fd_sc_hs__mux2i_1_0.S VGND sky130_fd_pr__nfet_01v8_lvt ad=0.2627 pd=2.19 as=0.13135 ps=1.095 w=0.74 l=0.15
X440 sky130_fd_sc_hs__a211oi_1_4.A1 sky130_fd_sc_hs__inv_1_5.A VPWR VPWR sky130_fd_pr__pfet_01v8 ad=0.3304 pd=2.83 as=0.3864 ps=2.93 w=1.12 l=0.15
X441 a_8586_2360# sky130_fd_sc_hs__a211oi_1_7.Y VGND VGND sky130_fd_pr__nfet_01v8_lvt ad=0.15563 pd=1.215 as=0.23015 ps=2.1 w=0.42 l=0.15
X442 a_10379_n6673# a_10227_n6668# VGND VGND sky130_fd_pr__nfet_01v8_lvt ad=0.10905 pd=1.025 as=0.1648 ps=1.245 w=0.55 l=0.15
X443 a_3529_n5953# digital_layout1_0.sky130_fd_sc_hs__dfxtp_1_4.Q digital_layout1_0.sky130_fd_sc_hs__mux2i_1_4.Y VPWR sky130_fd_pr__pfet_01v8 ad=0.3192 pd=2.81 as=0.168 ps=1.42 w=1.12 l=0.15
X444 a_4135_n737# sky130_fd_sc_hs__a211oi_1_6.A1 VPWR VPWR sky130_fd_pr__pfet_01v8 ad=0.168 pd=1.42 as=0.2184 ps=1.51 w=1.12 l=0.15
X445 a_n1804_2358# a_n2445_1929# a_n1911_2318# VPWR sky130_fd_pr__pfet_01v8 ad=0.0504 pd=0.66 as=0.09835 ps=1.005 w=0.42 l=0.15
X446 a_1623_2316# a_1089_1927# a_1516_2356# VGND sky130_fd_pr__nfet_01v8_lvt ad=0.07875 pd=0.865 as=0.15563 ps=1.215 w=0.42 l=0.15
X447 a_n3040_2365# a_n3952_2225# a_n3147_2281# VPWR sky130_fd_pr__pfet_01v8 ad=0.09975 pd=0.895 as=0.1428 ps=1.225 w=0.42 l=0.15
X448 a_11814_1319# rst VPWR VPWR sky130_fd_pr__pfet_01v8 ad=0.1512 pd=1.39 as=0.3304 ps=2.83 w=1.12 l=0.15
X449 a_5201_n6673# a_5049_n6668# VGND VGND sky130_fd_pr__nfet_01v8_lvt ad=0.10905 pd=1.025 as=0.1648 ps=1.245 w=0.55 l=0.15
X450 VPWR reset_cycle a_10360_n5953# VPWR sky130_fd_pr__pfet_01v8 ad=0.3346 pd=1.76 as=0.1134 ps=1.11 w=0.84 l=0.15
X451 digital_layout1_0.sky130_fd_sc_hs__nor3b_1_3.Y a_2199_n6209# VGND VGND sky130_fd_pr__nfet_01v8_lvt ad=0.2109 pd=2.05 as=0.1554 ps=1.16 w=0.74 l=0.15
X452 VGND clk a_n4131_1931# VGND sky130_fd_pr__nfet_01v8_lvt ad=0.1739 pd=1.21 as=0.2109 ps=2.05 w=0.74 l=0.15
X453 a_12527_2279# a_11543_1929# a_12229_2313# VPWR sky130_fd_pr__pfet_01v8 ad=0.1428 pd=1.225 as=0.2331 ps=1.395 w=0.84 l=0.15
X454 sky130_fd_sc_hs__a211oi_1_0.A1 sky130_fd_sc_hs__inv_1_0.A VPWR VPWR sky130_fd_pr__pfet_01v8 ad=0.3304 pd=2.83 as=0.3864 ps=2.93 w=1.12 l=0.15
X455 a_n2650_n5953# reset_cycle a_n2734_n5953# VPWR sky130_fd_pr__pfet_01v8 ad=0.2352 pd=1.54 as=0.1512 ps=1.39 w=1.12 l=0.15
X456 digital_layout1_0.sky130_fd_sc_hs__mux2i_1_1.Y counter.1 a_n1815_n5953# VPWR sky130_fd_pr__pfet_01v8 ad=0.168 pd=1.42 as=0.3136 ps=2.8 w=1.12 l=0.15
X457 VGND a_2246_n6817# a_2204_n7007# VGND sky130_fd_pr__nfet_01v8_lvt ad=0.1197 pd=1.41 as=0.05565 ps=0.685 w=0.42 l=0.15
X458 VGND a_n1210_n6817# a_n1252_n7007# VGND sky130_fd_pr__nfet_01v8_lvt ad=0.1197 pd=1.41 as=0.05565 ps=0.685 w=0.42 l=0.15
X459 sky130_fd_sc_hs__a211oi_1_2.Y sky130_fd_sc_hs__a211oi_1_2.A1 a_1585_n1035# VGND sky130_fd_pr__nfet_01v8_lvt ad=0.1443 pd=1.13 as=0.0777 ps=0.95 w=0.74 l=0.15
X460 a_n3289_1261# a_n3574_967# VPWR VPWR sky130_fd_pr__pfet_01v8 ad=0.308 pd=2.79 as=0.168 ps=1.42 w=1.12 l=0.15
X461 a_6973_n5953# a_6688_n6247# VPWR VPWR sky130_fd_pr__pfet_01v8 ad=0.308 pd=2.79 as=0.168 ps=1.42 w=1.12 l=0.15
X462 a_3327_2316# a_2972_2221# a_3220_2356# VPWR sky130_fd_pr__pfet_01v8 ad=0.09835 pd=1.005 as=0.09835 ps=1.005 w=0.42 l=0.15
X463 VGND a_10539_2313# a_10557_1956# VGND sky130_fd_pr__nfet_01v8_lvt ad=0.1648 pd=1.245 as=0.0441 ps=0.63 w=0.42 l=0.15
X464 VPWR sky130_fd_sc_hs__mux2i_1_1.A1 a_n2893_1005# VPWR sky130_fd_pr__pfet_01v8 ad=0.2345 pd=1.58 as=0.2478 ps=2.27 w=0.84 l=0.15
X465 sky130_fd_sc_hs__a211oi_1_2.A1 sky130_fd_sc_hs__inv_1_3.A VGND VGND sky130_fd_pr__nfet_01v8_lvt ad=0.2109 pd=2.05 as=0.2627 ps=2.19 w=0.74 l=0.15
X466 sky130_fd_sc_hs__a211oi_1_7.A1 sky130_fd_sc_hs__inv_1_6.A VGND VGND sky130_fd_pr__nfet_01v8_lvt ad=0.2109 pd=2.05 as=0.2627 ps=2.19 w=0.74 l=0.15
X467 a_n3583_n6668# a_n4117_n7057# a_n3690_n6628# VGND sky130_fd_pr__nfet_01v8_lvt ad=0.07875 pd=0.865 as=0.15563 ps=1.215 w=0.42 l=0.15
X468 sky130_fd_sc_hs__inv_1_2.A a_2272_2167# VPWR VPWR sky130_fd_pr__pfet_01v8 ad=0.3304 pd=2.83 as=0.1862 ps=1.475 w=1.12 l=0.15
X469 sky130_fd_sc_hs__a211oi_1_0.A1 sky130_fd_sc_hs__inv_1_0.A VGND VGND sky130_fd_pr__nfet_01v8_lvt ad=0.2109 pd=2.05 as=0.2627 ps=2.19 w=0.74 l=0.15
X470 a_n2266_2223# a_n2445_1929# VGND VGND sky130_fd_pr__nfet_01v8_lvt ad=0.2553 pd=2.17 as=0.1739 ps=1.21 w=0.74 l=0.15
X471 VGND digital_layout1_0.sky130_fd_sc_hs__mux2i_1_0.S a_5645_n6209# VGND sky130_fd_pr__nfet_01v8_lvt ad=0.13717 pd=1.13 as=0.2695 ps=2.08 w=0.55 l=0.15
X472 a_8697_n5953# digital_layout1_0.sky130_fd_sc_hs__dfxtp_1_7.Q digital_layout1_0.sky130_fd_sc_hs__mux2i_1_7.Y VPWR sky130_fd_pr__pfet_01v8 ad=0.3192 pd=2.81 as=0.168 ps=1.42 w=1.12 l=0.15
X473 VGND a_n1759_2313# a_n1741_1956# VGND sky130_fd_pr__nfet_01v8_lvt ad=0.1648 pd=1.245 as=0.0441 ps=0.63 w=0.42 l=0.15
X474 a_n3026_n6623# a_n3938_n6763# a_n3133_n6707# VPWR sky130_fd_pr__pfet_01v8 ad=0.09975 pd=0.895 as=0.1428 ps=1.225 w=0.42 l=0.15
X475 sky130_fd_sc_hs__a211oi_1_0.Y sky130_fd_sc_hs__a211oi_1_0.A1 a_n331_n1033# VGND sky130_fd_pr__nfet_01v8_lvt ad=0.1443 pd=1.13 as=0.0777 ps=0.95 w=0.74 l=0.15
X476 VGND digital_layout1_0.sky130_fd_sc_hs__nor3b_1_5.Y sky130_fd_sc_hs__a211oi_1_4.Y VGND sky130_fd_pr__nfet_01v8_lvt ad=0.1443 pd=1.13 as=0.1443 ps=1.13 w=0.74 l=0.15
X477 a_n1759_2313# a_n1911_2318# VPWR VPWR sky130_fd_pr__pfet_01v8 ad=0.2331 pd=1.395 as=0.18985 ps=1.545 w=0.84 l=0.15
X478 a_10379_n6673# a_10227_n6668# VPWR VPWR sky130_fd_pr__pfet_01v8 ad=0.2331 pd=1.395 as=0.18985 ps=1.545 w=0.84 l=0.15
X479 digital_layout1_0.sky130_fd_sc_hs__inv_1_1.Y reset_cycle VPWR VPWR sky130_fd_pr__pfet_01v8 ad=0.3304 pd=2.83 as=0.3864 ps=2.93 w=1.12 l=0.15
X480 a_n560_2223# a_n739_1929# VGND VGND sky130_fd_pr__nfet_01v8_lvt ad=0.2553 pd=2.17 as=0.1739 ps=1.21 w=0.74 l=0.15
X481 a_n3704_2360# sky130_fd_sc_hs__nor2_1_1.Y VPWR VPWR sky130_fd_pr__pfet_01v8 ad=0.09835 pd=1.005 as=0.2972 ps=2.41 w=0.42 l=0.15
X482 a_1516_2356# sky130_fd_sc_hs__a211oi_1_3.Y VPWR VPWR sky130_fd_pr__pfet_01v8 ad=0.09835 pd=1.005 as=0.2972 ps=2.41 w=0.42 l=0.15
X483 a_n3597_2320# a_n3952_2225# a_n3704_2360# VPWR sky130_fd_pr__pfet_01v8 ad=0.09835 pd=1.005 as=0.09835 ps=1.005 w=0.42 l=0.15
X484 a_1268_2221# a_1089_1927# VPWR VPWR sky130_fd_pr__pfet_01v8 ad=0.3304 pd=2.83 as=0.168 ps=1.42 w=1.12 l=0.15
X485 sky130_fd_sc_hs__inv_1_5.A a_7504_2171# VPWR VPWR sky130_fd_pr__pfet_01v8 ad=0.3304 pd=2.83 as=0.1862 ps=1.475 w=1.12 l=0.15
X486 a_6927_n6673# a_6775_n6668# VGND VGND sky130_fd_pr__nfet_01v8_lvt ad=0.10905 pd=1.025 as=0.1648 ps=1.245 w=0.55 l=0.15
X487 a_2438_n741# digital_layout1_0.sky130_fd_sc_hs__nor3b_1_4.Y a_2155_n741# VPWR sky130_fd_pr__pfet_01v8 ad=0.1848 pd=1.45 as=0.168 ps=1.42 w=1.12 l=0.15
X488 a_245_2279# a_n739_1929# a_n53_2313# VPWR sky130_fd_pr__pfet_01v8 ad=0.1428 pd=1.225 as=0.2331 ps=1.395 w=0.84 l=0.15
X489 VGND a_12779_1063# wenn VGND sky130_fd_pr__nfet_01v8_lvt ad=0.2627 pd=2.19 as=0.13135 ps=1.095 w=0.74 l=0.15
X490 sky130_fd_sc_hs__a211oi_1_3.A1 sky130_fd_sc_hs__inv_1_2.A VPWR VPWR sky130_fd_pr__pfet_01v8 ad=0.3304 pd=2.83 as=0.3864 ps=2.93 w=1.12 l=0.15
X491 a_n3355_n5953# digital_layout1_0.sky130_fd_sc_hs__dfxtp_1_0.Q digital_layout1_0.sky130_fd_sc_hs__mux2i_1_0.Y VPWR sky130_fd_pr__pfet_01v8 ad=0.3192 pd=2.81 as=0.168 ps=1.42 w=1.12 l=0.15
X492 a_5201_n6673# a_5049_n6668# VPWR VPWR sky130_fd_pr__pfet_01v8 ad=0.2331 pd=1.395 as=0.18985 ps=1.545 w=0.84 l=0.15
X493 a_3214_n6628# digital_layout1_0.sky130_fd_sc_hs__dfxtp_1_4.D VPWR VPWR sky130_fd_pr__pfet_01v8 ad=0.09835 pd=1.005 as=0.2972 ps=2.41 w=0.42 l=0.15
X494 a_3068_n739# digital_layout1_0.sky130_fd_sc_hs__nor3b_1_5.Y a_2785_n739# VPWR sky130_fd_pr__pfet_01v8 ad=0.1848 pd=1.45 as=0.168 ps=1.42 w=1.12 l=0.15
X495 VPWR digital_layout1_0.sky130_fd_sc_hs__mux2i_1_0.S a_9087_n6209# VPWR sky130_fd_pr__pfet_01v8 ad=0.2177 pd=1.54 as=0.2478 ps=2.27 w=0.84 l=0.15
X496 a_3244_n6247# digital_layout1_0.sky130_fd_sc_hs__mux2i_1_0.S VGND VGND sky130_fd_pr__nfet_01v8_lvt ad=0.15675 pd=1.67 as=0.15675 ps=1.67 w=0.55 l=0.15
X497 VPWR a_n1409_n6707# a_n1210_n6817# VPWR sky130_fd_pr__pfet_01v8 ad=0.1862 pd=1.475 as=0.2478 ps=2.27 w=0.84 l=0.15
X498 VGND reset_cycle digital_layout1_0.sky130_fd_sc_hs__nor3b_1_0.Y VGND sky130_fd_pr__nfet_01v8_lvt ad=0.1554 pd=1.16 as=0.1184 ps=1.06 w=0.74 l=0.15
X499 a_4418_n737# digital_layout1_0.sky130_fd_sc_hs__nor3b_1_7.Y a_4135_n737# VPWR sky130_fd_pr__pfet_01v8 ad=0.1848 pd=1.45 as=0.168 ps=1.42 w=1.12 l=0.15
X500 digital_layout1_0.sky130_fd_sc_hs__nor2_1_0.A a_10271_n5953# VPWR VPWR sky130_fd_pr__pfet_01v8 ad=0.3304 pd=2.83 as=0.3346 ps=1.76 w=1.12 l=0.15
X501 a_n1612_n6247# a_n1924_n6247# VGND VGND sky130_fd_pr__nfet_01v8_lvt ad=0.0888 pd=0.98 as=0.1554 ps=1.16 w=0.74 l=0.15
X502 a_n3938_n6763# a_n4117_n7057# VGND VGND sky130_fd_pr__nfet_01v8_lvt ad=0.2553 pd=2.17 as=0.1739 ps=1.21 w=0.74 l=0.15
X503 VGND digital_layout1_0.sky130_fd_sc_hs__mux2i_1_0.S a_n89_n6247# VGND sky130_fd_pr__nfet_01v8_lvt ad=0.1554 pd=1.16 as=0.2109 ps=2.05 w=0.74 l=0.15
X504 a_n53_2313# a_n205_2318# VGND VGND sky130_fd_pr__nfet_01v8_lvt ad=0.10905 pd=1.025 as=0.1648 ps=1.245 w=0.55 l=0.15
X505 VGND a_12726_2169# a_12684_1979# VGND sky130_fd_pr__nfet_01v8_lvt ad=0.1197 pd=1.41 as=0.05565 ps=0.685 w=0.42 l=0.15
X506 digital_layout1_0.sky130_fd_sc_hs__mux2i_1_1.Y counter.1 a_n1612_n6247# VGND sky130_fd_pr__nfet_01v8_lvt ad=0.26085 pd=1.445 as=0.0888 ps=0.98 w=0.74 l=0.15
X507 a_1749_n6673# a_1597_n6668# VPWR VPWR sky130_fd_pr__pfet_01v8 ad=0.2331 pd=1.395 as=0.18985 ps=1.545 w=0.84 l=0.15
X508 a_1242_n6763# a_1063_n7057# VPWR VPWR sky130_fd_pr__pfet_01v8 ad=0.3304 pd=2.83 as=0.168 ps=1.42 w=1.12 l=0.15
X509 a_1597_n6668# a_1063_n7057# a_1490_n6628# VGND sky130_fd_pr__nfet_01v8_lvt ad=0.07875 pd=0.865 as=0.15563 ps=1.215 w=0.42 l=0.15
X510 VGND a_n3431_n6673# a_n3413_n7030# VGND sky130_fd_pr__nfet_01v8_lvt ad=0.1648 pd=1.245 as=0.0441 ps=0.63 w=0.42 l=0.15
X511 VGND digital_layout1_0.sky130_fd_sc_hs__mux2i_1_0.S a_477_n6209# VGND sky130_fd_pr__nfet_01v8_lvt ad=0.13717 pd=1.13 as=0.2695 ps=2.08 w=0.55 l=0.15
X512 VPWR digital_layout1_0.sky130_fd_sc_hs__inv_1_1.Y a_n3465_1261# VPWR sky130_fd_pr__pfet_01v8 ad=0.168 pd=1.42 as=0.3136 ps=2.8 w=1.12 l=0.15
X513 a_5049_n6668# a_4694_n6763# a_4942_n6628# VPWR sky130_fd_pr__pfet_01v8 ad=0.09835 pd=1.005 as=0.09835 ps=1.005 w=0.42 l=0.15
X514 VGND clk a_2787_n7057# VGND sky130_fd_pr__nfet_01v8_lvt ad=0.1739 pd=1.21 as=0.2109 ps=2.05 w=0.74 l=0.15
X515 VPWR a_5605_2281# a_5804_2171# VPWR sky130_fd_pr__pfet_01v8 ad=0.1862 pd=1.475 as=0.2478 ps=2.27 w=0.84 l=0.15
X516 VGND digital_layout1_0.sky130_fd_sc_hs__inv_1_1.Y a_12211_1025# VGND sky130_fd_pr__nfet_01v8_lvt ad=0.1554 pd=1.16 as=0.2109 ps=2.05 w=0.74 l=0.15
X517 a_5249_n5953# digital_layout1_0.sky130_fd_sc_hs__dfxtp_1_5.Q digital_layout1_0.sky130_fd_sc_hs__mux2i_1_5.Y VPWR sky130_fd_pr__pfet_01v8 ad=0.3192 pd=2.81 as=0.168 ps=1.42 w=1.12 l=0.15
X518 digital_layout1_0.sky130_fd_sc_hs__dfxtp_1_2.Q a_518_n6817# VGND VGND sky130_fd_pr__nfet_01v8_lvt ad=0.2109 pd=2.05 as=0.1229 ps=1.085 w=0.74 l=0.15
X519 VPWR clk a_11543_1929# VPWR sky130_fd_pr__pfet_01v8 ad=0.168 pd=1.42 as=0.3304 ps=2.83 w=1.12 l=0.15
X520 digital_layout1_0.sky130_fd_sc_hs__dfxtp_1_5.Q a_5698_n6817# VGND VGND sky130_fd_pr__nfet_01v8_lvt ad=0.2109 pd=2.05 as=0.1229 ps=1.085 w=0.74 l=0.15
X521 a_7000_n6247# a_6688_n6247# VGND VGND sky130_fd_pr__nfet_01v8_lvt ad=0.0888 pd=0.98 as=0.1554 ps=1.16 w=0.74 l=0.15
X522 sky130_fd_sc_hs__inv_1_0.A a_n1262_2169# VGND VGND sky130_fd_pr__nfet_01v8_lvt ad=0.2109 pd=2.05 as=0.1229 ps=1.085 w=0.74 l=0.15
X523 a_1597_n6668# a_1242_n6763# a_1490_n6628# VPWR sky130_fd_pr__pfet_01v8 ad=0.09835 pd=1.005 as=0.09835 ps=1.005 w=0.42 l=0.15
X524 a_n238_n6628# digital_layout1_0.sky130_fd_sc_hs__dfxtp_1_2.D VGND VGND sky130_fd_pr__nfet_01v8_lvt ad=0.15563 pd=1.215 as=0.23015 ps=2.1 w=0.42 l=0.15
X525 a_5325_1958# a_4800_2225# a_5155_2320# VGND sky130_fd_pr__nfet_01v8_lvt ad=0.0441 pd=0.63 as=0.07875 ps=0.865 w=0.42 l=0.15
X526 sky130_fd_sc_hs__a211oi_1_1.Y sky130_fd_sc_hs__a211oi_1_1.A1 a_309_n1031# VGND sky130_fd_pr__nfet_01v8_lvt ad=0.1443 pd=1.13 as=0.0777 ps=0.95 w=0.74 l=0.15
X527 digital_layout1_0.sky130_fd_sc_hs__nor3b_1_2.Y a_477_n6209# a_794_n5953# VPWR sky130_fd_pr__pfet_01v8 ad=0.3304 pd=2.83 as=0.2352 ps=1.54 w=1.12 l=0.15
X528 a_6748_2360# sky130_fd_sc_hs__a211oi_1_4.Y VPWR VPWR sky130_fd_pr__pfet_01v8 ad=0.09835 pd=1.005 as=0.2972 ps=2.41 w=0.42 l=0.15
X529 a_2958_n5953# digital_layout1_0.sky130_fd_sc_hs__nor2_1_0.A VPWR VPWR sky130_fd_pr__pfet_01v8 ad=0.1512 pd=1.39 as=0.3304 ps=2.83 w=1.12 l=0.15
X530 VPWR a_1775_2311# a_1730_2356# VPWR sky130_fd_pr__pfet_01v8 ad=0.18985 pd=1.545 as=0.0504 ps=0.66 w=0.42 l=0.15
X531 a_10944_2363# a_10032_2223# a_10837_2279# VPWR sky130_fd_pr__pfet_01v8 ad=0.09975 pd=0.895 as=0.1428 ps=1.225 w=0.42 l=0.15
X532 a_10397_n7030# a_9872_n6763# a_10227_n6668# VGND sky130_fd_pr__nfet_01v8_lvt ad=0.0441 pd=0.63 as=0.07875 ps=0.865 w=0.42 l=0.15
X533 digital_layout1_0.sky130_fd_sc_hs__dfxtp_1_0.Q a_n2934_n6817# VPWR VPWR sky130_fd_pr__pfet_01v8 ad=0.3304 pd=2.83 as=0.1862 ps=1.475 w=1.12 l=0.15
X534 digital_layout1_0.sky130_fd_sc_hs__mux2i_1_3.Y counter.3 a_1633_n5953# VPWR sky130_fd_pr__pfet_01v8 ad=0.168 pd=1.42 as=0.3136 ps=2.8 w=1.12 l=0.15
X535 a_2972_2221# a_2793_1927# VGND VGND sky130_fd_pr__nfet_01v8_lvt ad=0.2553 pd=2.17 as=0.1739 ps=1.21 w=0.74 l=0.15
X536 digital_layout1_0.sky130_fd_sc_hs__dfxtp_1_3.Q a_2246_n6817# VGND VGND sky130_fd_pr__nfet_01v8_lvt ad=0.2109 pd=2.05 as=0.1229 ps=1.085 w=0.74 l=0.15
X537 a_3777_2277# a_2793_1927# a_3479_2311# VPWR sky130_fd_pr__pfet_01v8 ad=0.1428 pd=1.225 as=0.2331 ps=1.395 w=0.84 l=0.15
X538 a_2180_2361# a_1268_2221# a_2073_2277# VPWR sky130_fd_pr__pfet_01v8 ad=0.09975 pd=0.895 as=0.1428 ps=1.225 w=0.42 l=0.15
X539 a_5155_2320# a_4621_1931# a_5048_2360# VGND sky130_fd_pr__nfet_01v8_lvt ad=0.07875 pd=0.865 as=0.15563 ps=1.215 w=0.42 l=0.15
X540 sky130_fd_sc_hs__a211oi_1_6.Y rst VGND VGND sky130_fd_pr__nfet_01v8_lvt ad=0.1961 pd=2.01 as=0.1443 ps=1.13 w=0.74 l=0.15
X541 VGND a_5698_n6817# a_5656_n7007# VGND sky130_fd_pr__nfet_01v8_lvt ad=0.1197 pd=1.41 as=0.05565 ps=0.685 w=0.42 l=0.15
X542 VPWR a_21_n6673# a_n24_n6628# VPWR sky130_fd_pr__pfet_01v8 ad=0.18985 pd=1.545 as=0.0504 ps=0.66 w=0.42 l=0.15
X543 a_n3413_n7030# a_n3938_n6763# a_n3583_n6668# VGND sky130_fd_pr__nfet_01v8_lvt ad=0.0441 pd=0.63 as=0.07875 ps=0.865 w=0.42 l=0.15
X544 VPWR a_n1461_2279# a_n1262_2169# VPWR sky130_fd_pr__pfet_01v8 ad=0.1862 pd=1.475 as=0.2478 ps=2.27 w=0.84 l=0.15
X545 a_n1707_n6673# a_n1859_n6668# VGND VGND sky130_fd_pr__nfet_01v8_lvt ad=0.10905 pd=1.025 as=0.1648 ps=1.245 w=0.55 l=0.15
X546 VPWR a_444_2169# a_352_2363# VPWR sky130_fd_pr__pfet_01v8 ad=0.1239 pd=1.43 as=0.09975 ps=0.895 w=0.42 l=0.15
X547 a_5219_n7030# a_4694_n6763# a_5049_n6668# VGND sky130_fd_pr__nfet_01v8_lvt ad=0.0441 pd=0.63 as=0.07875 ps=0.865 w=0.42 l=0.15
X548 a_7412_2365# a_6500_2225# a_7305_2281# VPWR sky130_fd_pr__pfet_01v8 ad=0.09975 pd=0.895 as=0.1428 ps=1.225 w=0.42 l=0.15
X549 VPWR a_10837_2279# a_11036_2169# VPWR sky130_fd_pr__pfet_01v8 ad=0.1862 pd=1.475 as=0.2478 ps=2.27 w=0.84 l=0.15
X550 VGND a_10837_2279# a_11036_2169# VGND sky130_fd_pr__nfet_01v8_lvt ad=0.1229 pd=1.085 as=0.1824 ps=1.85 w=0.64 l=0.15
X551 VGND clk a_6241_n7057# VGND sky130_fd_pr__nfet_01v8_lvt ad=0.1739 pd=1.21 as=0.2109 ps=2.05 w=0.74 l=0.15
X552 a_n131_n6668# a_n665_n7057# a_n238_n6628# VGND sky130_fd_pr__nfet_01v8_lvt ad=0.07875 pd=0.865 as=0.15563 ps=1.215 w=0.42 l=0.15
X553 a_n3574_967# digital_layout1_0.sky130_fd_sc_hs__inv_1_1.Y VPWR VPWR sky130_fd_pr__pfet_01v8 ad=0.231 pd=2.23 as=0.2394 ps=2.25 w=0.84 l=0.15
X554 sky130_fd_sc_hs__inv_1_7.A a_11036_2169# VGND VGND sky130_fd_pr__nfet_01v8_lvt ad=0.2109 pd=2.05 as=0.1229 ps=1.085 w=0.74 l=0.15
X555 a_10120_n6628# digital_layout1_0.sky130_fd_sc_hs__dfxtp_1_8.D VPWR VPWR sky130_fd_pr__pfet_01v8 ad=0.09835 pd=1.005 as=0.2972 ps=2.41 w=0.42 l=0.15
X556 a_6402_n5953# digital_layout1_0.sky130_fd_sc_hs__nor2_1_0.A VPWR VPWR sky130_fd_pr__pfet_01v8 ad=0.1512 pd=1.39 as=0.3304 ps=2.83 w=1.12 l=0.15
X557 a_n3640_n6247# digital_layout1_0.sky130_fd_sc_hs__mux2i_1_0.S VGND VGND sky130_fd_pr__nfet_01v8_lvt ad=0.15675 pd=1.67 as=0.15675 ps=1.67 w=0.55 l=0.15
X558 VPWR a_n1759_2313# a_n1804_2358# VPWR sky130_fd_pr__pfet_01v8 ad=0.18985 pd=1.545 as=0.0504 ps=0.66 w=0.42 l=0.15
X559 digital_layout1_0.sky130_fd_sc_hs__dfxtp_1_7.Q a_9148_n6817# VPWR VPWR sky130_fd_pr__pfet_01v8 ad=0.3304 pd=2.83 as=0.1862 ps=1.475 w=1.12 l=0.15
X560 a_319_n6707# a_n486_n6763# a_21_n6673# VGND sky130_fd_pr__nfet_01v8_lvt ad=0.1181 pd=1.035 as=0.10905 ps=1.025 w=0.55 l=0.15
X561 VGND digital_layout1_0.sky130_fd_sc_hs__mux2i_1_0.S a_2199_n6209# VGND sky130_fd_pr__nfet_01v8_lvt ad=0.13717 pd=1.13 as=0.2695 ps=2.08 w=0.55 l=0.15
X562 a_11970_2358# sky130_fd_sc_hs__nor2_1_0.Y VPWR VPWR sky130_fd_pr__pfet_01v8 ad=0.09835 pd=1.005 as=0.2972 ps=2.41 w=0.42 l=0.15
X563 sky130_fd_sc_hs__a211oi_1_3.Y sky130_fd_sc_hs__a211oi_1_3.A1 a_955_n1035# VGND sky130_fd_pr__nfet_01v8_lvt ad=0.1443 pd=1.13 as=0.0777 ps=0.95 w=0.74 l=0.15
X564 VGND a_10379_n6673# a_10397_n7030# VGND sky130_fd_pr__nfet_01v8_lvt ad=0.1648 pd=1.245 as=0.0441 ps=0.63 w=0.42 l=0.15
X565 VPWR clk a_n665_n7057# VPWR sky130_fd_pr__pfet_01v8 ad=0.168 pd=1.42 as=0.3304 ps=2.83 w=1.12 l=0.15
X566 a_1809_n5953# digital_layout1_0.sky130_fd_sc_hs__dfxtp_1_3.Q digital_layout1_0.sky130_fd_sc_hs__mux2i_1_3.Y VPWR sky130_fd_pr__pfet_01v8 ad=0.3192 pd=2.81 as=0.168 ps=1.42 w=1.12 l=0.15
X567 a_n2976_n7007# a_n4117_n7057# a_n3133_n6707# VGND sky130_fd_pr__nfet_01v8_lvt ad=0.05565 pd=0.685 as=0.1181 ps=1.035 w=0.42 l=0.15
X568 a_5762_1981# a_4621_1931# a_5605_2281# VGND sky130_fd_pr__nfet_01v8_lvt ad=0.05565 pd=0.685 as=0.1181 ps=1.035 w=0.42 l=0.15
X569 a_5307_2315# a_5155_2320# VGND VGND sky130_fd_pr__nfet_01v8_lvt ad=0.10905 pd=1.025 as=0.1648 ps=1.245 w=0.55 l=0.15
X570 digital_layout1_0.sky130_fd_sc_hs__dfxtp_1_4.D digital_layout1_0.sky130_fd_sc_hs__nor2_1_0.A VGND VGND sky130_fd_pr__nfet_01v8_lvt ad=0.1036 pd=1.02 as=0.2109 ps=2.05 w=0.74 l=0.15
X571 VGND a_n1409_n6707# a_n1210_n6817# VGND sky130_fd_pr__nfet_01v8_lvt ad=0.1229 pd=1.085 as=0.1824 ps=1.85 w=0.64 l=0.15
X572 digital_layout1_0.sky130_fd_sc_hs__dfxtp_1_1.D digital_layout1_0.sky130_fd_sc_hs__mux2i_1_1.Y a_n2210_n5953# VPWR sky130_fd_pr__pfet_01v8 ad=0.3304 pd=2.83 as=0.1512 ps=1.39 w=1.12 l=0.15
X573 VGND a_21_n6673# a_39_n7030# VGND sky130_fd_pr__nfet_01v8_lvt ad=0.1648 pd=1.245 as=0.0441 ps=0.63 w=0.42 l=0.15
X574 digital_layout1_0.sky130_fd_sc_hs__nor3b_1_4.Y a_3921_n6209# VGND VGND sky130_fd_pr__nfet_01v8_lvt ad=0.2109 pd=2.05 as=0.1554 ps=1.16 w=0.74 l=0.15
X575 VGND a_n1461_2279# a_n1262_2169# VGND sky130_fd_pr__nfet_01v8_lvt ad=0.1229 pd=1.085 as=0.1824 ps=1.85 w=0.64 l=0.15
X576 a_8392_n6628# digital_layout1_0.sky130_fd_sc_hs__dfxtp_1_7.D VGND VGND sky130_fd_pr__nfet_01v8_lvt ad=0.15563 pd=1.215 as=0.23015 ps=2.1 w=0.42 l=0.15
X577 a_2047_n6707# a_1242_n6763# a_1749_n6673# VGND sky130_fd_pr__nfet_01v8_lvt ad=0.1181 pd=1.035 as=0.10905 ps=1.025 w=0.55 l=0.15
X578 VGND clk a_n2445_1929# VGND sky130_fd_pr__nfet_01v8_lvt ad=0.1739 pd=1.21 as=0.2109 ps=2.05 w=0.74 l=0.15
X579 sky130_fd_sc_hs__a211oi_1_5.A1 sky130_fd_sc_hs__inv_1_4.A VPWR VPWR sky130_fd_pr__pfet_01v8 ad=0.3304 pd=2.83 as=0.3864 ps=2.93 w=1.12 l=0.15
X580 VGND digital_layout1_0.sky130_fd_sc_hs__mux2i_1_0.S a_8523_n6247# VGND sky130_fd_pr__nfet_01v8_lvt ad=0.1554 pd=1.16 as=0.2109 ps=2.05 w=0.74 l=0.15
X581 VPWR digital_layout1_0.sky130_fd_sc_hs__mux2i_1_0.S a_5645_n6209# VPWR sky130_fd_pr__pfet_01v8 ad=0.2177 pd=1.54 as=0.2478 ps=2.27 w=0.84 l=0.15
X582 a_8800_2360# a_8159_1931# a_8693_2320# VPWR sky130_fd_pr__pfet_01v8 ad=0.0504 pd=0.66 as=0.09835 ps=1.005 w=0.42 l=0.15
X583 a_9056_n6623# a_8144_n6763# a_8949_n6707# VPWR sky130_fd_pr__pfet_01v8 ad=0.09975 pd=0.895 as=0.1428 ps=1.225 w=0.42 l=0.15
X584 VPWR a_3970_n6817# a_3878_n6623# VPWR sky130_fd_pr__pfet_01v8 ad=0.1239 pd=1.43 as=0.09975 ps=0.895 w=0.42 l=0.15
X585 a_9997_n6247# digital_layout1_0.sky130_fd_sc_hs__mux2i_1_0.S VGND VGND sky130_fd_pr__nfet_01v8_lvt ad=0.0888 pd=0.98 as=0.22412 ps=1.365 w=0.74 l=0.15
X586 a_8693_2320# a_8338_2225# a_8586_2360# VPWR sky130_fd_pr__pfet_01v8 ad=0.09835 pd=1.005 as=0.09835 ps=1.005 w=0.42 l=0.15
X587 VGND clk a_4515_n7057# VGND sky130_fd_pr__nfet_01v8_lvt ad=0.1739 pd=1.21 as=0.2109 ps=2.05 w=0.74 l=0.15
X588 VPWR a_319_n6707# a_518_n6817# VPWR sky130_fd_pr__pfet_01v8 ad=0.1862 pd=1.475 as=0.2478 ps=2.27 w=0.84 l=0.15
X589 VPWR a_3976_2167# a_3884_2361# VPWR sky130_fd_pr__pfet_01v8 ad=0.1239 pd=1.43 as=0.09975 ps=0.895 w=0.42 l=0.15
X590 VPWR digital_layout1_0.sky130_fd_sc_hs__mux2i_1_0.S a_n1245_n6209# VPWR sky130_fd_pr__pfet_01v8 ad=0.2177 pd=1.54 as=0.2478 ps=2.27 w=0.84 l=0.15
X591 a_3928_n7007# a_2787_n7057# a_3771_n6707# VGND sky130_fd_pr__nfet_01v8_lvt ad=0.05565 pd=0.685 as=0.1181 ps=1.035 w=0.42 l=0.15
X592 VGND digital_layout1_0.sky130_fd_sc_hs__mux2i_1_0.S a_7367_n6209# VGND sky130_fd_pr__nfet_01v8_lvt ad=0.13717 pd=1.13 as=0.2695 ps=2.08 w=0.55 l=0.15
X593 VGND clk a_n4117_n7057# VGND sky130_fd_pr__nfet_01v8_lvt ad=0.1739 pd=1.21 as=0.2109 ps=2.05 w=0.74 l=0.15
X594 a_4238_n5953# reset_cycle a_4154_n5953# VPWR sky130_fd_pr__pfet_01v8 ad=0.2352 pd=1.54 as=0.1512 ps=1.39 w=1.12 l=0.15
X595 a_n2214_n6763# a_n2393_n7057# VPWR VPWR sky130_fd_pr__pfet_01v8 ad=0.3304 pd=2.83 as=0.168 ps=1.42 w=1.12 l=0.15
X596 VGND digital_layout1_0.sky130_fd_sc_hs__mux2i_1_0.S a_n2967_n6209# VGND sky130_fd_pr__nfet_01v8_lvt ad=0.13717 pd=1.13 as=0.2695 ps=2.08 w=0.55 l=0.15
X597 a_9872_n6763# a_9693_n7057# VGND VGND sky130_fd_pr__nfet_01v8_lvt ad=0.2553 pd=2.17 as=0.1739 ps=1.21 w=0.74 l=0.15
X598 a_n1859_n6668# a_n2214_n6763# a_n1966_n6628# VPWR sky130_fd_pr__pfet_01v8 ad=0.09835 pd=1.005 as=0.09835 ps=1.005 w=0.42 l=0.15
X599 VPWR a_2047_n6707# a_2246_n6817# VPWR sky130_fd_pr__pfet_01v8 ad=0.1862 pd=1.475 as=0.2478 ps=2.27 w=0.84 l=0.15
X600 digital_layout1_0.sky130_fd_sc_hs__nor3b_1_6.Y a_7367_n6209# a_7684_n5953# VPWR sky130_fd_pr__pfet_01v8 ad=0.3304 pd=2.83 as=0.2352 ps=1.54 w=1.12 l=0.15
X601 a_1836_n6247# a_1524_n6247# VGND VGND sky130_fd_pr__nfet_01v8_lvt ad=0.0888 pd=0.98 as=0.1554 ps=1.16 w=0.74 l=0.15
X602 VGND clk a_8159_1931# VGND sky130_fd_pr__nfet_01v8_lvt ad=0.1739 pd=1.21 as=0.2109 ps=2.05 w=0.74 l=0.15
X603 VPWR a_5804_2171# a_5712_2365# VPWR sky130_fd_pr__pfet_01v8 ad=0.1239 pd=1.43 as=0.09975 ps=0.895 w=0.42 l=0.15
X604 VPWR clk a_n4131_1931# VPWR sky130_fd_pr__pfet_01v8 ad=0.168 pd=1.42 as=0.3304 ps=2.83 w=1.12 l=0.15
X605 a_8845_2315# a_8693_2320# VPWR VPWR sky130_fd_pr__pfet_01v8 ad=0.2331 pd=1.395 as=0.18985 ps=1.545 w=0.84 l=0.15
X606 digital_layout1_0.sky130_fd_sc_hs__dfxtp_1_0.D digital_layout1_0.sky130_fd_sc_hs__mux2i_1_0.Y a_n3926_n5953# VPWR sky130_fd_pr__pfet_01v8 ad=0.3304 pd=2.83 as=0.1512 ps=1.39 w=1.12 l=0.15
X607 digital_layout1_0.sky130_fd_sc_hs__mux2i_1_0.Y counter.0 a_n3531_n5953# VPWR sky130_fd_pr__pfet_01v8 ad=0.168 pd=1.42 as=0.3136 ps=2.8 w=1.12 l=0.15
X608 VPWR a_5307_2315# a_5262_2360# VPWR sky130_fd_pr__pfet_01v8 ad=0.18985 pd=1.545 as=0.0504 ps=0.66 w=0.42 l=0.15
X609 a_10280_2358# sky130_fd_sc_hs__a211oi_1_6.Y VGND VGND sky130_fd_pr__nfet_01v8_lvt ad=0.15563 pd=1.215 as=0.23015 ps=2.1 w=0.42 l=0.15
X610 VPWR digital_layout1_0.sky130_fd_sc_hs__mux2i_1_0.S a_477_n6209# VPWR sky130_fd_pr__pfet_01v8 ad=0.2177 pd=1.54 as=0.2478 ps=2.27 w=0.84 l=0.15
X611 VGND digital_layout1_0.sky130_fd_sc_hs__mux2i_1_0.S a_5075_n6247# VGND sky130_fd_pr__nfet_01v8_lvt ad=0.1554 pd=1.16 as=0.2109 ps=2.05 w=0.74 l=0.15
X612 VPWR a_8651_n6673# a_8606_n6628# VPWR sky130_fd_pr__pfet_01v8 ad=0.18985 pd=1.545 as=0.0504 ps=0.66 w=0.42 l=0.15
X613 digital_layout1_0.sky130_fd_sc_hs__dfxtp_1_2.D digital_layout1_0.sky130_fd_sc_hs__nor2_1_0.A VGND VGND sky130_fd_pr__nfet_01v8_lvt ad=0.1036 pd=1.02 as=0.2109 ps=2.05 w=0.74 l=0.15
X614 sky130_fd_sc_hs__mux2i_1_1.Y sky130_fd_sc_hs__mux2i_1_1.A0 a_n3262_967# VGND sky130_fd_pr__nfet_01v8_lvt ad=0.26085 pd=1.445 as=0.0888 ps=0.98 w=0.74 l=0.15
X615 VPWR a_n2934_n6817# a_n3026_n6623# VPWR sky130_fd_pr__pfet_01v8 ad=0.1239 pd=1.43 as=0.09975 ps=0.895 w=0.42 l=0.15
X616 a_8606_n6628# a_7965_n7057# a_8499_n6668# VPWR sky130_fd_pr__pfet_01v8 ad=0.0504 pd=0.66 as=0.09835 ps=1.005 w=0.42 l=0.15
X617 digital_layout1_0.sky130_fd_sc_hs__mux2i_1_6.Y counter.6 a_7000_n6247# VGND sky130_fd_pr__nfet_01v8_lvt ad=0.26085 pd=1.445 as=0.0888 ps=0.98 w=0.74 l=0.15
X618 VGND a_2272_2167# a_2230_1977# VGND sky130_fd_pr__nfet_01v8_lvt ad=0.1197 pd=1.41 as=0.05565 ps=0.685 w=0.42 l=0.15
X619 a_n136_n739# digital_layout1_0.sky130_fd_sc_hs__nor3b_1_0.Y a_n419_n739# VPWR sky130_fd_pr__pfet_01v8 ad=0.1848 pd=1.45 as=0.168 ps=1.42 w=1.12 l=0.15
X620 a_7305_2281# a_6321_1931# a_7007_2315# VPWR sky130_fd_pr__pfet_01v8 ad=0.1428 pd=1.225 as=0.2331 ps=1.395 w=0.84 l=0.15
X621 VGND reset_cycle digital_layout1_0.sky130_fd_sc_hs__nor3b_1_7.Y VGND sky130_fd_pr__nfet_01v8_lvt ad=0.1554 pd=1.16 as=0.1184 ps=1.06 w=0.74 l=0.15
X622 VGND digital_layout1_0.sky130_fd_sc_hs__inv_1_1.Y a_n3463_967# VGND sky130_fd_pr__nfet_01v8_lvt ad=0.1554 pd=1.16 as=0.2109 ps=2.05 w=0.74 l=0.15
X623 VGND a_8949_n6707# a_9148_n6817# VGND sky130_fd_pr__nfet_01v8_lvt ad=0.1229 pd=1.085 as=0.1824 ps=1.85 w=0.64 l=0.15
X624 a_21_n6673# a_n131_n6668# VGND VGND sky130_fd_pr__nfet_01v8_lvt ad=0.10905 pd=1.025 as=0.1648 ps=1.245 w=0.55 l=0.15
X625 VPWR a_7225_n6707# a_7424_n6817# VPWR sky130_fd_pr__pfet_01v8 ad=0.1862 pd=1.475 as=0.2478 ps=2.27 w=0.84 l=0.15
X626 a_n3431_n6673# a_n3583_n6668# VPWR VPWR sky130_fd_pr__pfet_01v8 ad=0.2331 pd=1.395 as=0.18985 ps=1.545 w=0.84 l=0.15
X627 a_352_2363# a_n560_2223# a_245_2279# VPWR sky130_fd_pr__pfet_01v8 ad=0.09975 pd=0.895 as=0.1428 ps=1.225 w=0.42 l=0.15
X628 VGND a_5307_2315# a_5325_1958# VGND sky130_fd_pr__nfet_01v8_lvt ad=0.1648 pd=1.245 as=0.0441 ps=0.63 w=0.42 l=0.15
X629 a_n1304_1979# a_n2445_1929# a_n1461_2279# VGND sky130_fd_pr__nfet_01v8_lvt ad=0.05565 pd=0.685 as=0.1181 ps=1.035 w=0.42 l=0.15
X630 a_1730_2356# a_1089_1927# a_1623_2316# VPWR sky130_fd_pr__pfet_01v8 ad=0.0504 pd=0.66 as=0.09835 ps=1.005 w=0.42 l=0.15
X631 a_1238_n5953# digital_layout1_0.sky130_fd_sc_hs__nor2_1_0.A VPWR VPWR sky130_fd_pr__pfet_01v8 ad=0.1512 pd=1.39 as=0.3304 ps=2.83 w=1.12 l=0.15
X632 digital_layout1_0.sky130_fd_sc_hs__nand2b_1_0.Y a_9755_n6209# a_9997_n6247# VGND sky130_fd_pr__nfet_01v8_lvt ad=0.3182 pd=2.34 as=0.0888 ps=0.98 w=0.74 l=0.15
X633 VGND digital_layout1_0.sky130_fd_sc_hs__mux2i_1_1.Y digital_layout1_0.sky130_fd_sc_hs__dfxtp_1_1.D VGND sky130_fd_pr__nfet_01v8_lvt ad=0.2109 pd=2.05 as=0.1036 ps=1.02 w=0.74 l=0.15
X634 a_10032_2223# a_9853_1929# VGND VGND sky130_fd_pr__nfet_01v8_lvt ad=0.2553 pd=2.17 as=0.1739 ps=1.21 w=0.74 l=0.15
X635 digital_layout1_0.sky130_fd_sc_hs__nor3b_1_3.Y a_2199_n6209# a_2516_n5953# VPWR sky130_fd_pr__pfet_01v8 ad=0.3304 pd=2.83 as=0.2352 ps=1.54 w=1.12 l=0.15
X636 a_n3328_n6247# a_n3640_n6247# VGND VGND sky130_fd_pr__nfet_01v8_lvt ad=0.0888 pd=0.98 as=0.1554 ps=1.16 w=0.74 l=0.15
X637 VPWR digital_layout1_0.sky130_fd_sc_hs__nand2b_1_0.Y a_n419_n739# VPWR sky130_fd_pr__pfet_01v8 ad=0.2184 pd=1.51 as=0.308 ps=2.79 w=1.12 l=0.15
X638 a_n1911_2318# a_n2445_1929# a_n2018_2358# VGND sky130_fd_pr__nfet_01v8_lvt ad=0.07875 pd=0.865 as=0.15563 ps=1.215 w=0.42 l=0.15
X639 VPWR clk a_7965_n7057# VPWR sky130_fd_pr__pfet_01v8 ad=0.168 pd=1.42 as=0.3304 ps=2.83 w=1.12 l=0.15
X640 VPWR clk a_6321_1931# VPWR sky130_fd_pr__pfet_01v8 ad=0.168 pd=1.42 as=0.3304 ps=2.83 w=1.12 l=0.15
X641 digital_layout1_0.sky130_fd_sc_hs__mux2i_1_0.Y counter.0 a_n3328_n6247# VGND sky130_fd_pr__nfet_01v8_lvt ad=0.26085 pd=1.445 as=0.0888 ps=0.98 w=0.74 l=0.15
X642 a_n3133_n6707# a_n4117_n7057# a_n3431_n6673# VPWR sky130_fd_pr__pfet_01v8 ad=0.1428 pd=1.225 as=0.2331 ps=1.395 w=0.84 l=0.15
X643 a_867_n741# sky130_fd_sc_hs__a211oi_1_3.A1 VPWR VPWR sky130_fd_pr__pfet_01v8 ad=0.168 pd=1.42 as=0.2184 ps=1.51 w=1.12 l=0.15
X644 a_n1252_n7007# a_n2393_n7057# a_n1409_n6707# VGND sky130_fd_pr__nfet_01v8_lvt ad=0.05565 pd=0.685 as=0.1181 ps=1.035 w=0.42 l=0.15
X645 a_6945_n7030# a_6420_n6763# a_6775_n6668# VGND sky130_fd_pr__nfet_01v8_lvt ad=0.0441 pd=0.63 as=0.07875 ps=0.865 w=0.42 l=0.15
X646 VPWR digital_layout1_0.sky130_fd_sc_hs__mux2i_1_0.S a_n91_n5953# VPWR sky130_fd_pr__pfet_01v8 ad=0.168 pd=1.42 as=0.3136 ps=2.8 w=1.12 l=0.15
X647 a_n2018_2358# sky130_fd_sc_hs__a211oi_1_0.Y VGND VGND sky130_fd_pr__nfet_01v8_lvt ad=0.15563 pd=1.215 as=0.23015 ps=2.1 w=0.42 l=0.15
X648 sky130_fd_sc_hs__a211oi_1_0.Y rst a_n136_n739# VPWR sky130_fd_pr__pfet_01v8 ad=0.308 pd=2.79 as=0.1848 ps=1.45 w=1.12 l=0.15
X649 digital_layout1_0.sky130_fd_sc_hs__mux2i_1_2.Y counter.2 a_112_n6247# VGND sky130_fd_pr__nfet_01v8_lvt ad=0.26085 pd=1.445 as=0.0888 ps=0.98 w=0.74 l=0.15
X650 a_9320_n5953# counter.7 VPWR VPWR sky130_fd_pr__pfet_01v8 ad=0.1512 pd=1.39 as=0.2177 ps=1.54 w=1.12 l=0.15
X651 a_n3574_967# digital_layout1_0.sky130_fd_sc_hs__inv_1_1.Y VGND VGND sky130_fd_pr__nfet_01v8_lvt ad=0.15675 pd=1.67 as=0.15675 ps=1.67 w=0.55 l=0.15
X652 digital_layout1_0.sky130_fd_sc_hs__nor3b_1_7.Y counter.7 VGND VGND sky130_fd_pr__nfet_01v8_lvt ad=0.1184 pd=1.06 as=0.13717 ps=1.13 w=0.74 l=0.15
X653 a_n3952_2225# a_n4131_1931# VGND VGND sky130_fd_pr__nfet_01v8_lvt ad=0.2553 pd=2.17 as=0.1739 ps=1.21 w=0.74 l=0.15
X654 VPWR digital_layout1_0.sky130_fd_sc_hs__mux2i_1_0.S a_2199_n6209# VPWR sky130_fd_pr__pfet_01v8 ad=0.2177 pd=1.54 as=0.2478 ps=2.27 w=0.84 l=0.15
X655 a_1775_2311# a_1623_2316# VPWR VPWR sky130_fd_pr__pfet_01v8 ad=0.2331 pd=1.395 as=0.18985 ps=1.545 w=0.84 l=0.15
X656 VGND digital_layout1_0.sky130_fd_sc_hs__nor3b_1_3.Y sky130_fd_sc_hs__a211oi_1_2.Y VGND sky130_fd_pr__nfet_01v8_lvt ad=0.1443 pd=1.13 as=0.1443 ps=1.13 w=0.74 l=0.15
X657 VGND a_7504_2171# a_7462_1981# VGND sky130_fd_pr__nfet_01v8_lvt ad=0.1197 pd=1.41 as=0.05565 ps=0.685 w=0.42 l=0.15
X658 VPWR digital_layout1_0.sky130_fd_sc_hs__nand2b_1_0.Y a_2155_n741# VPWR sky130_fd_pr__pfet_01v8 ad=0.2184 pd=1.51 as=0.308 ps=2.79 w=1.12 l=0.15
X659 VGND clk a_4621_1931# VGND sky130_fd_pr__nfet_01v8_lvt ad=0.1739 pd=1.21 as=0.2109 ps=2.05 w=0.74 l=0.15
X660 VPWR a_7305_2281# a_7504_2171# VPWR sky130_fd_pr__pfet_01v8 ad=0.1862 pd=1.475 as=0.2478 ps=2.27 w=0.84 l=0.15
X661 a_n419_n739# sky130_fd_sc_hs__a211oi_1_0.A1 VPWR VPWR sky130_fd_pr__pfet_01v8 ad=0.168 pd=1.42 as=0.2184 ps=1.51 w=1.12 l=0.15
X662 a_n1759_2313# a_n1911_2318# VGND VGND sky130_fd_pr__nfet_01v8_lvt ad=0.10905 pd=1.025 as=0.1648 ps=1.245 w=0.55 l=0.15
X663 a_8412_n6247# digital_layout1_0.sky130_fd_sc_hs__mux2i_1_0.S VPWR VPWR sky130_fd_pr__pfet_01v8 ad=0.231 pd=2.23 as=0.2394 ps=2.25 w=0.84 l=0.15
X664 VPWR a_5499_n6707# a_5698_n6817# VPWR sky130_fd_pr__pfet_01v8 ad=0.1862 pd=1.475 as=0.2478 ps=2.27 w=0.84 l=0.15
X665 a_3884_2361# a_2972_2221# a_3777_2277# VPWR sky130_fd_pr__pfet_01v8 ad=0.09975 pd=0.895 as=0.1428 ps=1.225 w=0.42 l=0.15
X666 VPWR digital_layout1_0.sky130_fd_sc_hs__nand2b_1_0.Y a_4135_n737# VPWR sky130_fd_pr__pfet_01v8 ad=0.2184 pd=1.51 as=0.308 ps=2.79 w=1.12 l=0.15
X667 digital_layout1_0.sky130_fd_sc_hs__dfxtp_1_3.D digital_layout1_0.sky130_fd_sc_hs__nor2_1_0.A VGND VGND sky130_fd_pr__nfet_01v8_lvt ad=0.1036 pd=1.02 as=0.2109 ps=2.05 w=0.74 l=0.15
X668 a_1793_1954# a_1268_2221# a_1623_2316# VGND sky130_fd_pr__nfet_01v8_lvt ad=0.0441 pd=0.63 as=0.07875 ps=0.865 w=0.42 l=0.15
X669 sky130_fd_sc_hs__a211oi_1_2.A1 sky130_fd_sc_hs__inv_1_3.A VPWR VPWR sky130_fd_pr__pfet_01v8 ad=0.3304 pd=2.83 as=0.3864 ps=2.93 w=1.12 l=0.15
X670 sky130_fd_sc_hs__a211oi_1_4.Y rst VGND VGND sky130_fd_pr__nfet_01v8_lvt ad=0.1961 pd=2.01 as=0.1443 ps=1.13 w=0.74 l=0.15
X671 a_1775_2311# a_1623_2316# VGND VGND sky130_fd_pr__nfet_01v8_lvt ad=0.10905 pd=1.025 as=0.1648 ps=1.245 w=0.55 l=0.15
X672 a_2966_n6763# a_2787_n7057# VGND VGND sky130_fd_pr__nfet_01v8_lvt ad=0.2553 pd=2.17 as=0.1739 ps=1.21 w=0.74 l=0.15
X673 a_7025_1958# a_6500_2225# a_6855_2320# VGND sky130_fd_pr__nfet_01v8_lvt ad=0.0441 pd=0.63 as=0.07875 ps=0.865 w=0.42 l=0.15
X674 a_309_n1031# digital_layout1_0.sky130_fd_sc_hs__nand2b_1_0.Y VGND VGND sky130_fd_pr__nfet_01v8_lvt ad=0.0777 pd=0.95 as=0.1961 ps=2.01 w=0.74 l=0.15
X675 a_7382_n7007# a_6241_n7057# a_7225_n6707# VGND sky130_fd_pr__nfet_01v8_lvt ad=0.05565 pd=0.685 as=0.1181 ps=1.035 w=0.42 l=0.15
X676 VPWR a_n53_2313# a_n98_2358# VPWR sky130_fd_pr__pfet_01v8 ad=0.18985 pd=1.545 as=0.0504 ps=0.66 w=0.42 l=0.15
X677 VPWR a_3777_2277# a_3976_2167# VPWR sky130_fd_pr__pfet_01v8 ad=0.1862 pd=1.475 as=0.2478 ps=2.27 w=0.84 l=0.15
X678 VGND a_3777_2277# a_3976_2167# VGND sky130_fd_pr__nfet_01v8_lvt ad=0.1229 pd=1.085 as=0.1824 ps=1.85 w=0.64 l=0.15
X679 digital_layout1_0.sky130_fd_sc_hs__nor3b_1_1.Y a_n1245_n6209# a_n928_n5953# VPWR sky130_fd_pr__pfet_01v8 ad=0.3304 pd=2.83 as=0.2352 ps=1.54 w=1.12 l=0.15
X680 VPWR digital_layout1_0.sky130_fd_sc_hs__mux2i_1_0.S a_7367_n6209# VPWR sky130_fd_pr__pfet_01v8 ad=0.2177 pd=1.54 as=0.2478 ps=2.27 w=0.84 l=0.15
X681 a_6500_2225# a_6321_1931# VPWR VPWR sky130_fd_pr__pfet_01v8 ad=0.3304 pd=2.83 as=0.168 ps=1.42 w=1.12 l=0.15
X682 a_9300_1981# a_8159_1931# a_9143_2281# VGND sky130_fd_pr__nfet_01v8_lvt ad=0.05565 pd=0.685 as=0.1181 ps=1.035 w=0.42 l=0.15
X683 a_12100_1025# digital_layout1_0.sky130_fd_sc_hs__inv_1_1.Y VGND VGND sky130_fd_pr__nfet_01v8_lvt ad=0.15675 pd=1.67 as=0.15675 ps=1.67 w=0.55 l=0.15
X684 a_8845_2315# a_8693_2320# VGND VGND sky130_fd_pr__nfet_01v8_lvt ad=0.10905 pd=1.025 as=0.1648 ps=1.245 w=0.55 l=0.15
X685 a_1150_n741# digital_layout1_0.sky130_fd_sc_hs__nor3b_1_2.Y a_867_n741# VPWR sky130_fd_pr__pfet_01v8 ad=0.1848 pd=1.45 as=0.168 ps=1.42 w=1.12 l=0.15
X686 VPWR digital_layout1_0.sky130_fd_sc_hs__nand2b_1_0.Y a_867_n741# VPWR sky130_fd_pr__pfet_01v8 ad=0.2184 pd=1.51 as=0.308 ps=2.79 w=1.12 l=0.15
X687 a_6855_2320# a_6321_1931# a_6748_2360# VGND sky130_fd_pr__nfet_01v8_lvt ad=0.07875 pd=0.865 as=0.15563 ps=1.215 w=0.42 l=0.15
X688 VPWR a_11036_2169# a_10944_2363# VPWR sky130_fd_pr__pfet_01v8 ad=0.1239 pd=1.43 as=0.09975 ps=0.895 w=0.42 l=0.15
X689 VGND sky130_fd_sc_hs__mux2i_1_1.Y sky130_fd_sc_hs__nor2_1_1.Y VGND sky130_fd_pr__nfet_01v8_lvt ad=0.2109 pd=2.05 as=0.1036 ps=1.02 w=0.74 l=0.15
X690 sky130_fd_sc_hs__inv_1_3.A a_3976_2167# VGND VGND sky130_fd_pr__nfet_01v8_lvt ad=0.2109 pd=2.05 as=0.1229 ps=1.085 w=0.74 l=0.15
X691 VPWR a_n3147_2281# a_n2948_2171# VPWR sky130_fd_pr__pfet_01v8 ad=0.1862 pd=1.475 as=0.2478 ps=2.27 w=0.84 l=0.15
X692 sky130_fd_sc_hs__mux2i_1_0.Y sky130_fd_sc_hs__mux2i_1_0.A0 a_12209_1319# VPWR sky130_fd_pr__pfet_01v8 ad=0.168 pd=1.42 as=0.3136 ps=2.8 w=1.12 l=0.15
X693 VPWR clk a_n2393_n7057# VPWR sky130_fd_pr__pfet_01v8 ad=0.168 pd=1.42 as=0.3304 ps=2.83 w=1.12 l=0.15
X694 VGND digital_layout1_0.sky130_fd_sc_hs__mux2i_1_7.Y digital_layout1_0.sky130_fd_sc_hs__dfxtp_1_7.D VGND sky130_fd_pr__nfet_01v8_lvt ad=0.2109 pd=2.05 as=0.1036 ps=1.02 w=0.74 l=0.15
X695 digital_layout1_0.sky130_fd_sc_hs__dfxtp_1_6.D digital_layout1_0.sky130_fd_sc_hs__mux2i_1_6.Y a_6402_n5953# VPWR sky130_fd_pr__pfet_01v8 ad=0.3304 pd=2.83 as=0.1512 ps=1.39 w=1.12 l=0.15
X696 a_5262_2360# a_4621_1931# a_5155_2320# VPWR sky130_fd_pr__pfet_01v8 ad=0.0504 pd=0.66 as=0.09835 ps=1.005 w=0.42 l=0.15
X697 sky130_fd_sc_hs__nor2_1_0.Y sky130_fd_sc_hs__mux2i_1_0.Y a_11814_1319# VPWR sky130_fd_pr__pfet_01v8 ad=0.3304 pd=2.83 as=0.1512 ps=1.39 w=1.12 l=0.15
X698 a_3771_n6707# a_2787_n7057# a_3473_n6673# VPWR sky130_fd_pr__pfet_01v8 ad=0.1428 pd=1.225 as=0.2331 ps=1.395 w=0.84 l=0.15
X699 digital_layout1_0.sky130_fd_sc_hs__inv_1_1.Y reset_cycle VGND VGND sky130_fd_pr__nfet_01v8_lvt ad=0.2109 pd=2.05 as=0.2627 ps=2.19 w=0.74 l=0.15
X700 a_5155_2320# a_4800_2225# a_5048_2360# VPWR sky130_fd_pr__pfet_01v8 ad=0.09835 pd=1.005 as=0.09835 ps=1.005 w=0.42 l=0.15
X701 VGND reset_cycle digital_layout1_0.sky130_fd_sc_hs__nor3b_1_5.Y VGND sky130_fd_pr__nfet_01v8_lvt ad=0.1554 pd=1.16 as=0.1184 ps=1.06 w=0.74 l=0.15
X702 sky130_fd_sc_hs__nor2_1_1.Y rst VGND VGND sky130_fd_pr__nfet_01v8_lvt ad=0.1036 pd=1.02 as=0.2109 ps=2.05 w=0.74 l=0.15
X703 a_7305_2281# a_6500_2225# a_7007_2315# VGND sky130_fd_pr__nfet_01v8_lvt ad=0.1181 pd=1.035 as=0.10905 ps=1.025 w=0.55 l=0.15
X704 sky130_fd_sc_hs__a211oi_1_7.Y rst VGND VGND sky130_fd_pr__nfet_01v8_lvt ad=0.1961 pd=2.01 as=0.1443 ps=1.13 w=0.74 l=0.15
X705 digital_layout1_0.sky130_fd_sc_hs__dfxtp_1_4.Q a_3970_n6817# VPWR VPWR sky130_fd_pr__pfet_01v8 ad=0.3304 pd=2.83 as=0.1862 ps=1.475 w=1.12 l=0.15
X706 a_n3529_n6247# digital_layout1_0.sky130_fd_sc_hs__dfxtp_1_0.Q digital_layout1_0.sky130_fd_sc_hs__mux2i_1_0.Y VGND sky130_fd_pr__nfet_01v8_lvt ad=0.2109 pd=2.05 as=0.26085 ps=1.445 w=0.74 l=0.15
X707 a_n2210_n5953# digital_layout1_0.sky130_fd_sc_hs__nor2_1_0.A VPWR VPWR sky130_fd_pr__pfet_01v8 ad=0.1512 pd=1.39 as=0.3304 ps=2.83 w=1.12 l=0.15
X708 VGND a_9148_n6817# a_9106_n7007# VGND sky130_fd_pr__nfet_01v8_lvt ad=0.1197 pd=1.41 as=0.05565 ps=0.685 w=0.42 l=0.15
X709 digital_layout1_0.sky130_fd_sc_hs__nor3b_1_1.Y a_n1245_n6209# VGND VGND sky130_fd_pr__nfet_01v8_lvt ad=0.2109 pd=2.05 as=0.1554 ps=1.16 w=0.74 l=0.15
X710 a_n98_2358# a_n739_1929# a_n205_2318# VPWR sky130_fd_pr__pfet_01v8 ad=0.0504 pd=0.66 as=0.09835 ps=1.005 w=0.42 l=0.15
X711 VGND a_444_2169# a_402_1979# VGND sky130_fd_pr__nfet_01v8_lvt ad=0.1197 pd=1.41 as=0.05565 ps=0.685 w=0.42 l=0.15
X712 digital_layout1_0.sky130_fd_sc_hs__nor2_1_0.A a_10271_n5953# VGND VGND sky130_fd_pr__nfet_01v8_lvt ad=0.2109 pd=2.05 as=0.15198 ps=1.17 w=0.74 l=0.15
X713 VPWR clk a_8159_1931# VPWR sky130_fd_pr__pfet_01v8 ad=0.168 pd=1.42 as=0.3304 ps=2.83 w=1.12 l=0.15
X714 VPWR a_9342_2171# a_9250_2365# VPWR sky130_fd_pr__pfet_01v8 ad=0.1239 pd=1.43 as=0.09975 ps=0.895 w=0.42 l=0.15
X715 sky130_fd_sc_hs__a211oi_1_5.Y rst VGND VGND sky130_fd_pr__nfet_01v8_lvt ad=0.1961 pd=2.01 as=0.1443 ps=1.13 w=0.74 l=0.15
X716 sky130_fd_sc_hs__a211oi_1_7.Y rst a_3786_n737# VPWR sky130_fd_pr__pfet_01v8 ad=0.308 pd=2.79 as=0.1848 ps=1.45 w=1.12 l=0.15
X717 a_1749_n6673# a_1597_n6668# VGND VGND sky130_fd_pr__nfet_01v8_lvt ad=0.10905 pd=1.025 as=0.1648 ps=1.245 w=0.55 l=0.15
X718 a_39_n7030# a_n486_n6763# a_n131_n6668# VGND sky130_fd_pr__nfet_01v8_lvt ad=0.0441 pd=0.63 as=0.07875 ps=0.865 w=0.42 l=0.15
X719 a_3214_n6628# digital_layout1_0.sky130_fd_sc_hs__dfxtp_1_4.D VGND VGND sky130_fd_pr__nfet_01v8_lvt ad=0.15563 pd=1.215 as=0.23015 ps=2.1 w=0.42 l=0.15
X720 a_n2642_1261# sky130_fd_sc_hs__mux2i_1_1.A0 VPWR VPWR sky130_fd_pr__pfet_01v8 ad=0.1512 pd=1.39 as=0.2345 ps=1.58 w=1.12 l=0.15
X721 a_5307_2315# a_5155_2320# VPWR VPWR sky130_fd_pr__pfet_01v8 ad=0.2331 pd=1.395 as=0.18985 ps=1.545 w=0.84 l=0.15
X722 a_12385_1319# sky130_fd_sc_hs__mux2i_1_0.A1 sky130_fd_sc_hs__mux2i_1_0.Y VPWR sky130_fd_pr__pfet_01v8 ad=0.3192 pd=2.81 as=0.168 ps=1.42 w=1.12 l=0.15
X723 a_8949_n6707# a_7965_n7057# a_8651_n6673# VPWR sky130_fd_pr__pfet_01v8 ad=0.1428 pd=1.225 as=0.2331 ps=1.395 w=0.84 l=0.15
X724 a_7225_n6707# a_6241_n7057# a_6927_n6673# VPWR sky130_fd_pr__pfet_01v8 ad=0.1428 pd=1.225 as=0.2331 ps=1.395 w=0.84 l=0.15
X725 VGND reset_cycle digital_layout1_0.sky130_fd_sc_hs__nor3b_1_2.Y VGND sky130_fd_pr__nfet_01v8_lvt ad=0.1554 pd=1.16 as=0.1184 ps=1.06 w=0.74 l=0.15
X726 a_2230_1977# a_1089_1927# a_2073_2277# VGND sky130_fd_pr__nfet_01v8_lvt ad=0.05565 pd=0.685 as=0.1181 ps=1.035 w=0.42 l=0.15
X727 a_3321_n6668# a_2966_n6763# a_3214_n6628# VPWR sky130_fd_pr__pfet_01v8 ad=0.09835 pd=1.005 as=0.09835 ps=1.005 w=0.42 l=0.15
X728 digital_layout1_0.sky130_fd_sc_hs__nor3b_1_5.Y counter.5 VGND VGND sky130_fd_pr__nfet_01v8_lvt ad=0.1184 pd=1.06 as=0.13717 ps=1.13 w=0.74 l=0.15
X729 VGND digital_layout1_0.sky130_fd_sc_hs__mux2i_1_0.S a_1635_n6247# VGND sky130_fd_pr__nfet_01v8_lvt ad=0.1554 pd=1.16 as=0.2109 ps=2.05 w=0.74 l=0.15
X730 a_11722_2223# a_11543_1929# VPWR VPWR sky130_fd_pr__pfet_01v8 ad=0.3304 pd=2.83 as=0.168 ps=1.42 w=1.12 l=0.15
X731 a_n1966_n6628# digital_layout1_0.sky130_fd_sc_hs__dfxtp_1_1.D VGND VGND sky130_fd_pr__nfet_01v8_lvt ad=0.15563 pd=1.215 as=0.23015 ps=2.1 w=0.42 l=0.15
X732 digital_layout1_0.sky130_fd_sc_hs__nor3b_1_4.Y a_3921_n6209# a_4238_n5953# VPWR sky130_fd_pr__pfet_01v8 ad=0.3304 pd=2.83 as=0.2352 ps=1.54 w=1.12 l=0.15
X733 sky130_fd_sc_hs__mux2i_1_1.A0 a_n2948_2171# VGND VGND sky130_fd_pr__nfet_01v8_lvt ad=0.2109 pd=2.05 as=0.1229 ps=1.085 w=0.74 l=0.15
X734 a_4694_n6763# a_4515_n7057# VGND VGND sky130_fd_pr__nfet_01v8_lvt ad=0.2553 pd=2.17 as=0.1739 ps=1.21 w=0.74 l=0.15
X735 a_3220_2356# sky130_fd_sc_hs__a211oi_1_2.Y VGND VGND sky130_fd_pr__nfet_01v8_lvt ad=0.15563 pd=1.215 as=0.23015 ps=2.1 w=0.42 l=0.15
X736 a_n3926_n5953# digital_layout1_0.sky130_fd_sc_hs__nor2_1_0.A VPWR VPWR sky130_fd_pr__pfet_01v8 ad=0.1512 pd=1.39 as=0.3304 ps=2.83 w=1.12 l=0.15
X737 sky130_fd_sc_hs__inv_1_6.A a_9342_2171# VPWR VPWR sky130_fd_pr__pfet_01v8 ad=0.3304 pd=2.83 as=0.1862 ps=1.475 w=1.12 l=0.15
X738 a_8651_n6673# a_8499_n6668# VPWR VPWR sky130_fd_pr__pfet_01v8 ad=0.2331 pd=1.395 as=0.18985 ps=1.545 w=0.84 l=0.15
X739 a_n2214_n6763# a_n2393_n7057# VGND VGND sky130_fd_pr__nfet_01v8_lvt ad=0.2553 pd=2.17 as=0.1739 ps=1.21 w=0.74 l=0.15
X740 sky130_fd_sc_hs__a211oi_1_6.A1 sky130_fd_sc_hs__inv_1_7.A VGND VGND sky130_fd_pr__nfet_01v8_lvt ad=0.2109 pd=2.05 as=0.2627 ps=2.19 w=0.74 l=0.15
X741 a_8144_n6763# a_7965_n7057# VPWR VPWR sky130_fd_pr__pfet_01v8 ad=0.3304 pd=2.83 as=0.168 ps=1.42 w=1.12 l=0.15
X742 a_8499_n6668# a_7965_n7057# a_8392_n6628# VGND sky130_fd_pr__nfet_01v8_lvt ad=0.07875 pd=0.865 as=0.15563 ps=1.215 w=0.42 l=0.15
X743 VGND a_n3147_2281# a_n2948_2171# VGND sky130_fd_pr__nfet_01v8_lvt ad=0.1229 pd=1.085 as=0.1824 ps=1.85 w=0.64 l=0.15
X744 VGND a_3976_2167# a_3934_1977# VGND sky130_fd_pr__nfet_01v8_lvt ad=0.1197 pd=1.41 as=0.05565 ps=0.685 w=0.42 l=0.15
X745 VPWR digital_layout1_0.sky130_fd_sc_hs__mux2i_1_0.S a_8521_n5953# VPWR sky130_fd_pr__pfet_01v8 ad=0.168 pd=1.42 as=0.3136 ps=2.8 w=1.12 l=0.15
X746 sky130_fd_sc_hs__inv_1_1.A a_444_2169# VPWR VPWR sky130_fd_pr__pfet_01v8 ad=0.3304 pd=2.83 as=0.1862 ps=1.475 w=1.12 l=0.15
X747 VGND clk a_1063_n7057# VGND sky130_fd_pr__nfet_01v8_lvt ad=0.1739 pd=1.21 as=0.2109 ps=2.05 w=0.74 l=0.15
X748 a_5048_2360# sky130_fd_sc_hs__a211oi_1_5.Y VGND VGND sky130_fd_pr__nfet_01v8_lvt ad=0.15563 pd=1.215 as=0.23015 ps=2.1 w=0.42 l=0.15
X749 a_8338_2225# a_8159_1931# VPWR VPWR sky130_fd_pr__pfet_01v8 ad=0.3304 pd=2.83 as=0.168 ps=1.42 w=1.12 l=0.15
X750 VGND a_3970_n6817# a_3928_n7007# VGND sky130_fd_pr__nfet_01v8_lvt ad=0.1197 pd=1.41 as=0.05565 ps=0.685 w=0.42 l=0.15
X751 VPWR a_3473_n6673# a_3428_n6628# VPWR sky130_fd_pr__pfet_01v8 ad=0.18985 pd=1.545 as=0.0504 ps=0.66 w=0.42 l=0.15
X752 a_4800_2225# a_4621_1931# VGND VGND sky130_fd_pr__nfet_01v8_lvt ad=0.2553 pd=2.17 as=0.1739 ps=1.21 w=0.74 l=0.15
X753 a_12527_2279# a_11722_2223# a_12229_2313# VGND sky130_fd_pr__nfet_01v8_lvt ad=0.1181 pd=1.035 as=0.10905 ps=1.025 w=0.55 l=0.15
X754 sky130_fd_sc_hs__a211oi_1_4.A1 sky130_fd_sc_hs__inv_1_5.A VGND VGND sky130_fd_pr__nfet_01v8_lvt ad=0.2109 pd=2.05 as=0.2627 ps=2.19 w=0.74 l=0.15
X755 VPWR clk a_9853_1929# VPWR sky130_fd_pr__pfet_01v8 ad=0.168 pd=1.42 as=0.3304 ps=2.83 w=1.12 l=0.15
X756 a_n3289_1261# sky130_fd_sc_hs__mux2i_1_1.A1 sky130_fd_sc_hs__mux2i_1_1.Y VPWR sky130_fd_pr__pfet_01v8 ad=0.3192 pd=2.81 as=0.168 ps=1.42 w=1.12 l=0.15
X757 a_8499_n6668# a_8144_n6763# a_8392_n6628# VPWR sky130_fd_pr__pfet_01v8 ad=0.09835 pd=1.005 as=0.09835 ps=1.005 w=0.42 l=0.15
X758 a_3428_n6628# a_2787_n7057# a_3321_n6668# VPWR sky130_fd_pr__pfet_01v8 ad=0.0504 pd=0.66 as=0.09835 ps=1.005 w=0.42 l=0.15
X759 a_710_n5953# counter.2 VPWR VPWR sky130_fd_pr__pfet_01v8 ad=0.1512 pd=1.39 as=0.2177 ps=1.54 w=1.12 l=0.15
X760 digital_layout1_0.sky130_fd_sc_hs__nor3b_1_2.Y counter.2 VGND VGND sky130_fd_pr__nfet_01v8_lvt ad=0.1184 pd=1.06 as=0.13717 ps=1.13 w=0.74 l=0.15
X761 VPWR clk a_2793_1927# VPWR sky130_fd_pr__pfet_01v8 ad=0.168 pd=1.42 as=0.3304 ps=2.83 w=1.12 l=0.15
X762 VPWR digital_layout1_0.sky130_fd_sc_hs__mux2i_1_0.S a_n2967_n6209# VPWR sky130_fd_pr__pfet_01v8 ad=0.2177 pd=1.54 as=0.2478 ps=2.27 w=0.84 l=0.15
X763 reset_cycle a_10876_n6817# VPWR VPWR sky130_fd_pr__pfet_01v8 ad=0.3304 pd=2.83 as=0.1862 ps=1.475 w=1.12 l=0.15
X764 a_n1741_1956# a_n2266_2223# a_n1911_2318# VGND sky130_fd_pr__nfet_01v8_lvt ad=0.0441 pd=0.63 as=0.07875 ps=0.865 w=0.42 l=0.15
X765 VGND clk a_n739_1929# VGND sky130_fd_pr__nfet_01v8_lvt ad=0.1739 pd=1.21 as=0.2109 ps=2.05 w=0.74 l=0.15
X766 a_6420_n6763# a_6241_n7057# VGND VGND sky130_fd_pr__nfet_01v8_lvt ad=0.2553 pd=2.17 as=0.1739 ps=1.21 w=0.74 l=0.15
X767 digital_layout1_0.sky130_fd_sc_hs__dfxtp_1_6.D digital_layout1_0.sky130_fd_sc_hs__nor2_1_0.A VGND VGND sky130_fd_pr__nfet_01v8_lvt ad=0.1036 pd=1.02 as=0.2109 ps=2.05 w=0.74 l=0.15
.ends
