* NGSPICE file created from all.ext - technology: sky130A
* %s/\v<sky130_fd_sc_hs__([a-zA-Z0-9]+_\d+)>/nd_\1/g

.subckt nd_o21ba_1 A1 A2 B1_N VGND VNB VPB VPWR X a_200_392# a_116_392#
+ a_281_244# a_27_74#
X0 a_116_392# A1.t1 VPWR.t2 VPB.t1 sky130_fd_pr__pfet_01v8 ad=0.135 pd=1.27 as=0.295 ps=2.59 w=1 l=0.15
X1 VGND.t2 B1_N.t0 a_281_244# VNB.t0 sky130_fd_pr__nfet_01v8_lvt ad=0.14495 pd=1.16 as=0.275 ps=2.1 w=0.55 l=0.15
X2 VPWR.t0 B1_N.t1 a_281_244# VPB.t0 sky130_fd_pr__pfet_01v8 ad=0.231 pd=1.555 as=0.3108 ps=2.42 w=0.84 l=0.15
X3 VGND.t0 A1.t0 a_27_74# VNB.t1 sky130_fd_pr__nfet_01v8_lvt ad=0.1344 pd=1.06 as=0.1824 ps=1.85 w=0.64 l=0.15
X4 a_200_392# a_281_244# a_27_74# VNB.t3 sky130_fd_pr__nfet_01v8_lvt ad=0.2176 pd=1.96 as=0.0944 ps=0.935 w=0.64 l=0.15
X5 a_200_392# A2.t1 a_116_392# VPB.t4 sky130_fd_pr__pfet_01v8 ad=0.21 pd=1.42 as=0.135 ps=1.27 w=1 l=0.15
X6 VPWR.t3 a_281_244# a_200_392# VPB.t3 sky130_fd_pr__pfet_01v8 ad=0.295 pd=2.59 as=0.21 ps=1.42 w=1 l=0.15
X7 a_27_74# A2.t0 VGND.t3 VNB.t4 sky130_fd_pr__nfet_01v8_lvt ad=0.0944 pd=0.935 as=0.1344 ps=1.06 w=0.64 l=0.15
X8 X.t1 a_200_392# VPWR.t1 VPB.t2 sky130_fd_pr__pfet_01v8 ad=0.3304 pd=2.83 as=0.231 ps=1.555 w=1.12 l=0.15
X9 X.t0 a_200_392# VGND.t1 VNB.t2 sky130_fd_pr__nfet_01v8_lvt ad=0.2109 pd=2.05 as=0.14495 ps=1.16 w=0.74 l=0.15
R0 VGND.n2 VGND.n0 211.155
R1 VGND.n2 VGND.n1 125.219
R2 VGND.n1 VGND.t2 51.509
R3 VGND.n0 VGND.t3 39.3755
R4 VGND.n0 VGND.t0 39.3755
R5 VGND.n1 VGND.t1 28.7381
R6 VGND VGND.n2 0.200367
R7 X.n1 X 589.444
R8 X.n1 X.n0 585
R9 X.n2 X.n1 585
R10 X X.t0 206.069
R11 X.n1 X.t1 26.3844
R12 X.n2 X 11.9116
R13 X.n0 X 10.3116
R14 X.n0 X 2.84494
R15 X X.n2 1.24494
R16 B1_N.n0 B1_N.t1 240.732
R17 B1_N B1_N.n0 158.788
R18 B1_N.n0 B1_N.t0 147.814
R19 VPWR.n1 VPWR.t3 820.029
R20 VPWR.n3 VPWR.n2 669.462
R21 VPWR.n7 VPWR.t2 251.702
R22 VPWR.n2 VPWR.t0 60.9767
R23 VPWR.n6 VPWR.n5 36.1417
R24 VPWR.n2 VPWR.t1 32.6589
R25 VPWR.n5 VPWR.n1 26.7299
R26 VPWR.n7 VPWR.n6 20.7064
R27 VPWR.n8 VPWR.n7 9.3005
R28 VPWR.n6 VPWR.n0 9.3005
R29 VPWR.n5 VPWR.n4 9.3005
R30 VPWR.n3 VPWR.n1 6.89086
R31 VPWR.n4 VPWR.n3 0.244332
R32 VPWR.n8 VPWR.n0 0.122949
R33 VPWR.n4 VPWR.n0 0.122949
R34 VPWR VPWR.n8 0.0617245
R35 A2.n0 A2.t1 231.629
R36 A2.n1 A2.t0 165.488
R37 A2.n0 A2 153.468
R38 A2.n2 A2.n1 152
R39 A2.n1 A2.n0 49.6611
R40 A2.n2 A2 7.6005
R41 A2 A2.n2 2.26717
R42 A1.n0 A1.t1 232.321
R43 A1.n1 A1.t0 164.111
R44 A1.n0 A1 153.656
R45 A1.n2 A1.n1 152
R46 A1.n1 A1.n0 46.8234
R47 A1.n2 A1 8.58403
R48 A1 A1.n2 2.5605
R49 VPB.t3 VPB.t0 640.995
R50 VPB.t0 VPB.t2 298.791
R51 VPB.t4 VPB.t3 291.13
R52 VPB VPB.t1 257.93
R53 VPB.t1 VPB.t4 214.517
R54 VNB.t3 VNB.t0 2910.24
R55 VNB.t0 VNB.t2 1316.54
R56 VNB.t1 VNB.t4 1316.54
R57 VNB VNB.t1 1143.31
R58 VNB.t4 VNB.t3 1027.82
C0 VGND A1 0.01487f
C1 X VGND 0.09663f
C2 a_200_392# VPB 0.0741f
C3 B1_N a_200_392# 0.07757f
C4 VPWR A1 0.05499f
C5 VPWR X 0.07004f
C6 a_200_392# a_27_74# 0.05424f
C7 A2 a_281_244# 0.07854f
C8 VPB A1 0.04732f
C9 X VPB 0.01449f
C10 A2 VGND 0.01594f
C11 a_27_74# A1 0.05086f
C12 VPWR a_116_392# 0.01675f
C13 A2 VPWR 0.02223f
C14 VGND a_281_244# 0.08324f
C15 X a_200_392# 0.12375f
C16 A2 VPB 0.04251f
C17 VPWR a_281_244# 0.02774f
C18 A2 a_27_74# 0.05321f
C19 VPWR VGND 0.06339f
C20 VPB a_281_244# 0.08073f
C21 B1_N a_281_244# 0.1008f
C22 A2 a_200_392# 0.07334f
C23 VGND VPB 0.01073f
C24 B1_N VGND 0.01716f
C25 VGND a_27_74# 0.1641f
C26 A2 A1 0.10831f
C27 VPWR VPB 0.14974f
C28 a_200_392# a_281_244# 0.26892f
C29 VGND a_200_392# 0.08705f
C30 B1_N VPB 0.04203f
C31 VPWR a_200_392# 0.25441f
C32 VGND VNB 0.54523f
C33 X VNB 0.25595f
C34 B1_N VNB 0.15299f
C35 VPWR VNB 0.42174f
C36 A2 VNB 0.19931f
C37 A1 VNB 0.22638f
C38 VPB VNB 0.99051f
C39 a_27_74# VNB 0.0357f
C40 a_200_392# VNB 0.13428f
C41 a_281_244# VNB 0.16867f
C42 VPB.t2 VNB 0.10848f
C43 VPB.t0 VNB 0.10106f
C44 VPB.t3 VNB 0.10024f
C45 VPB.t4 VNB 0.05438f
C46 VPB.t1 VNB 0.05081f
C47 A1.t1 VNB 0.04106f
C48 A1.n0 VNB 0.059f
C49 A1.t0 VNB 0.0256f
C50 A1.n1 VNB 0.05176f
C51 A1.n2 VNB 0.02872f
C52 A2.t1 VNB 0.05588f
C53 A2.n0 VNB 0.07744f
C54 A2.t0 VNB 0.03489f
C55 A2.n1 VNB 0.06693f
C56 A2.n2 VNB 0.04409f
C57 VPWR.n0 VNB 0.0364f
C58 VPWR.t2 VNB 0.04759f
C59 VPWR.t3 VNB 0.04213f
C60 VPWR.n1 VNB 0.05325f
C61 VPWR.t0 VNB 0.0169f
C62 VPWR.n2 VNB 0.05082f
C63 VPWR.n3 VNB 0.18407f
C64 VPWR.n4 VNB 0.10897f
C65 VPWR.n5 VNB 0.01098f
C66 VPWR.n7 VNB 0.07244f
C67 VPWR.n8 VNB 0.0273f
C68 B1_N.t1 VNB 0.05673f
C69 B1_N.t0 VNB 0.03246f
C70 B1_N.n0 VNB 0.10004f
C71 X.t1 VNB 0.01954f
C72 X.n0 VNB 0.01549f
C73 X.n1 VNB 0.05745f
C74 X.n2 VNB 0.01549f
C75 X.t0 VNB 0.06644f
C76 VGND.t3 VNB 0.01043f
C77 VGND.t0 VNB 0.01043f
C78 VGND.n0 VNB 0.02401f
C79 VGND.t2 VNB 0.01035f
C80 VGND.n1 VNB 0.03854f
C81 VGND.n2 VNB 0.40988f
.ends

.subckt nd_nor2b_1 A B_N VGND VNB VPB VPWR Y a_27_112#
X0 Y.t2 A.t0 VGND.t2 VNB.t0 sky130_fd_pr__nfet_01v8_lvt ad=0.13135 pd=1.095 as=0.15358 ps=1.2 w=0.74 l=0.15
X1 Y.t1 a_27_112# a_278_368# VPB.t2 sky130_fd_pr__pfet_01v8 ad=0.42 pd=2.99 as=0.1512 ps=1.39 w=1.12 l=0.15
X2 a_278_368# A.t1 VPWR.t1 VPB.t0 sky130_fd_pr__pfet_01v8 ad=0.1512 pd=1.39 as=0.2345 ps=1.58 w=1.12 l=0.15
X3 VGND.t0 B_N.t0 a_27_112# VNB.t1 sky130_fd_pr__nfet_01v8_lvt ad=0.15358 pd=1.2 as=0.2805 ps=2.12 w=0.55 l=0.15
X4 VGND.t1 a_27_112# Y.t0 VNB.t2 sky130_fd_pr__nfet_01v8_lvt ad=0.2627 pd=2.19 as=0.13135 ps=1.095 w=0.74 l=0.15
X5 VPWR.t0 B_N.t1 a_27_112# VPB.t1 sky130_fd_pr__pfet_01v8 ad=0.2345 pd=1.58 as=0.2478 ps=2.27 w=0.84 l=0.15
R0 VGND.n1 VGND.t1 244.565
R1 VGND.n1 VGND.n0 126.425
R2 VGND.n0 VGND.t0 69.1152
R3 VGND.n0 VGND.t2 21.9332
R4 VGND VGND.n1 0.633775
R5 Y.n1 Y 588.636
R6 Y.n2 Y.n1 585
R7 Y.n1 Y.n0 585
R8 Y Y.n3 190.779
R9 Y.n3 Y.t2 34.8654
R10 Y.n1 Y.t1 27.2639
R11 Y.n3 Y.t0 22.7032
R12 Y.n2 Y 9.74595
R13 Y.n0 Y 8.43686
R14 Y.n0 Y 2.32777
R15 Y Y.n2 1.01868
R16 B_N.n0 B_N.t1 219.846
R17 B_N B_N.n0 219.404
R18 B_N.n0 B_N.t0 128.288
R19 VPWR VPWR.n0 238.133
R20 VPWR.n0 VPWR.t0 72.7029
R21 VPWR.n0 VPWR.t1 29.6087
R22 A.n0 A.t1 283.113
R23 A.n0 A.t0 175.736
R24 A A.n0 158.788
R25 VPB VPB.t1 360.082
R26 VPB.t1 VPB.t0 311.56
R27 VPB.t0 VPB.t2 214.517
R28 VNB VNB.t1 1662.99
R29 VNB.t1 VNB.t0 1408.92
R30 VNB.t0 VNB.t2 1166.4
C0 VPB VPWR 0.09356f
C1 VPWR a_278_368# 0.01647f
C2 B_N a_27_112# 0.10928f
C3 B_N VGND 0.01411f
C4 B_N A 0.03529f
C5 VGND a_27_112# 0.09069f
C6 A a_27_112# 0.14755f
C7 A VGND 0.04542f
C8 VPB B_N 0.0582f
C9 Y a_27_112# 0.12878f
C10 Y VGND 0.1556f
C11 B_N VPWR 0.01692f
C12 Y A 0.01454f
C13 VPB a_27_112# 0.05975f
C14 VPB A 0.03417f
C15 VPWR a_27_112# 0.13319f
C16 VPWR VGND 0.04023f
C17 A VPWR 0.02332f
C18 VPB Y 0.0185f
C19 Y VPWR 0.08539f
C20 VGND VNB 0.48769f
C21 Y VNB 0.24889f
C22 B_N VNB 0.2234f
C23 VPWR VNB 0.58628f
C24 A VNB 0.15037f
C25 VPB VNB 0.67353f
C26 a_27_112# VNB 0.17442f
C27 VPB.t2 VNB 0.10411f
C28 VPB.t0 VNB 0.05035f
C29 VPB.t1 VNB 0.06428f
C30 A.t1 VNB 0.07341f
C31 A.t0 VNB 0.0437f
C32 A.n0 VNB 0.11854f
C33 VPWR.t0 VNB 0.02179f
C34 VPWR.n0 VNB 0.0604f
C35 B_N.t1 VNB 0.03919f
C36 B_N.t0 VNB 0.02127f
C37 B_N.n0 VNB 0.11174f
C38 Y.t1 VNB 0.02236f
C39 Y.n0 VNB 0.02097f
C40 Y.n1 VNB 0.08599f
C41 Y.n2 VNB 0.02097f
C42 Y.t0 VNB 0.01334f
C43 Y.t2 VNB 0.02049f
C44 Y.n3 VNB 0.07302f
C45 VGND.t0 VNB 0.01196f
C46 VGND.n0 VNB 0.03642f
C47 VGND.t1 VNB 0.03649f
C48 VGND.n1 VNB 0.14979f
.ends

.subckt nd_clkinv_1 A VGND VNB VPB VPWR Y
X0 Y.t2 A.t2 VPWR.t1 VPB.t0 sky130_fd_pr__pfet_01v8 ad=0.126 pd=1.14 as=0.2394 ps=2.25 w=0.84 l=0.15
X1 Y.t0 A.t0 VGND.t0 VNB.t0 sky130_fd_pr__nfet_01v8_lvt ad=0.22535 pd=2.17 as=0.1491 ps=1.55 w=0.42 l=0.15
X2 VPWR.t0 A.t1 Y.t1 VPB.t1 sky130_fd_pr__pfet_01v8 ad=0.2394 pd=2.25 as=0.126 ps=1.14 w=0.84 l=0.15
R0 VGND VGND.t0 273.411
R1 Y Y.n0 312.115
R2 Y.n1 Y.t0 166.948
R3 Y.n0 Y.t2 35.1791
R4 Y.n0 Y.t1 35.1791
R5 Y Y.n1 11.382
R6 Y.n1 Y 0.638642
R7 VPWR.n0 VPWR.t0 785.482
R8 VPWR.n0 VPWR.t1 427.678
R9 VPWR VPWR.n0 0.548572
R10 A.n1 A.t1 189.855
R11 A.n1 A.t2 189.855
R12 A A.n4 156.294
R13 A.n2 A 155.76
R14 A.n3 A.n0 152
R15 A.n4 A.t0 121.877
R16 A.n4 A.n3 26.0132
R17 A.n3 A.n2 26.0132
R18 A.n2 A.n1 12.6243
R19 A A.n0 4.36875
R20 A A.n0 3.14971
R21 VPB VPB.t0 252.823
R22 VPB.t0 VPB.t1 229.839
R23 VNB VNB.t0 1402.2
C0 Y VPB 0.01622f
C1 VPWR A 0.05568f
C2 VGND A 0.04561f
C3 Y A 0.15742f
C4 VPWR VGND 0.02485f
C5 VPWR Y 0.16881f
C6 VPB A 0.1081f
C7 VPWR VPB 0.06229f
C8 Y VGND 0.10193f
C9 VGND VNB 0.40628f
C10 Y VNB 0.38542f
C11 VPWR VNB 0.33244f
C12 A VNB 0.36397f
C13 VPB VNB 0.45234f
C14 VPB.t1 VNB 0.09592f
C15 VPB.t0 VNB 0.0498f
C16 A.n0 VNB 0.03075f
C17 A.t1 VNB 0.0233f
C18 A.t2 VNB 0.0233f
C19 A.n1 VNB 0.04016f
C20 A.n2 VNB 0.04208f
C21 A.n3 VNB 0.05651f
C22 A.t0 VNB 0.01201f
C23 A.n4 VNB 0.06082f
C24 VPWR.t0 VNB 0.03818f
C25 VPWR.t1 VNB 0.03822f
C26 VPWR.n0 VNB 0.1331f
C27 Y.t1 VNB 0.01926f
C28 Y.t2 VNB 0.01926f
C29 Y.n0 VNB 0.04338f
C30 Y.t0 VNB 0.04555f
C31 Y.n1 VNB 0.04351f
C32 VGND.t0 VNB 0.02031f
.ends

.subckt nd_dfxtp_1 CLK D VGND VNB VPB VPWR Q a_1011_424# a_1210_314#
+ a_561_463# a_27_74# a_206_368# a_713_458#
X0 VPWR.t7 CLK.t1 a_27_74# VPB.t9 sky130_fd_pr__pfet_01v8 ad=0.168 pd=1.42 as=0.3304 ps=2.83 w=1.12 l=0.15
X1 a_668_503# a_27_74# a_561_463# VPB.t1 sky130_fd_pr__pfet_01v8 ad=0.0504 pd=0.66 as=0.09835 ps=1.005 w=0.42 l=0.15
X2 Q.t0 a_1210_314# VPWR.t4 VPB.t6 sky130_fd_pr__pfet_01v8 ad=0.3304 pd=2.83 as=0.1862 ps=1.475 w=1.12 l=0.15
X3 a_454_503# D.t1 VPWR.t6 VPB.t8 sky130_fd_pr__pfet_01v8 ad=0.09835 pd=1.005 as=0.2972 ps=2.41 w=0.42 l=0.15
X4 VPWR.t2 a_1011_424# a_1210_314# VPB.t4 sky130_fd_pr__pfet_01v8 ad=0.1862 pd=1.475 as=0.2478 ps=2.27 w=0.84 l=0.15
X5 VGND.t7 CLK.t0 a_27_74# VNB.t9 sky130_fd_pr__nfet_01v8_lvt ad=0.1739 pd=1.21 as=0.2109 ps=2.05 w=0.74 l=0.15
X6 a_1118_508# a_206_368# a_1011_424# VPB.t11 sky130_fd_pr__pfet_01v8 ad=0.09975 pd=0.895 as=0.1428 ps=1.225 w=0.42 l=0.15
X7 VGND.t4 a_1210_314# a_1168_124# VNB.t5 sky130_fd_pr__nfet_01v8_lvt ad=0.1197 pd=1.41 as=0.05565 ps=0.685 w=0.42 l=0.15
X8 a_713_458# a_561_463# VGND.t6 VNB.t7 sky130_fd_pr__nfet_01v8_lvt ad=0.10905 pd=1.025 as=0.1648 ps=1.245 w=0.55 l=0.15
X9 VGND.t2 a_713_458# a_731_101# VNB.t3 sky130_fd_pr__nfet_01v8_lvt ad=0.1648 pd=1.245 as=0.0441 ps=0.63 w=0.42 l=0.15
X10 a_561_463# a_206_368# a_454_503# VPB.t10 sky130_fd_pr__pfet_01v8 ad=0.09835 pd=1.005 as=0.09835 ps=1.005 w=0.42 l=0.15
X11 a_206_368# a_27_74# VPWR.t0 VPB.t0 sky130_fd_pr__pfet_01v8 ad=0.3304 pd=2.83 as=0.168 ps=1.42 w=1.12 l=0.15
X12 a_1011_424# a_27_74# a_713_458# VPB.t2 sky130_fd_pr__pfet_01v8 ad=0.1428 pd=1.225 as=0.2331 ps=1.395 w=0.84 l=0.15
X13 VPWR.t3 a_1210_314# a_1118_508# VPB.t5 sky130_fd_pr__pfet_01v8 ad=0.1239 pd=1.43 as=0.09975 ps=0.895 w=0.42 l=0.15
X14 a_1168_124# a_27_74# a_1011_424# VNB.t2 sky130_fd_pr__nfet_01v8_lvt ad=0.05565 pd=0.685 as=0.1181 ps=1.035 w=0.42 l=0.15
X15 Q.t1 a_1210_314# VGND.t5 VNB.t6 sky130_fd_pr__nfet_01v8_lvt ad=0.2109 pd=2.05 as=0.1229 ps=1.085 w=0.74 l=0.15
X16 a_713_458# a_561_463# VPWR.t5 VPB.t7 sky130_fd_pr__pfet_01v8 ad=0.2331 pd=1.395 as=0.18985 ps=1.545 w=0.84 l=0.15
X17 a_561_463# a_27_74# a_454_503# VNB.t1 sky130_fd_pr__nfet_01v8_lvt ad=0.07875 pd=0.865 as=0.15563 ps=1.215 w=0.42 l=0.15
X18 VPWR.t1 a_713_458# a_668_503# VPB.t3 sky130_fd_pr__pfet_01v8 ad=0.18985 pd=1.545 as=0.0504 ps=0.66 w=0.42 l=0.15
X19 VGND.t3 a_1011_424# a_1210_314# VNB.t4 sky130_fd_pr__nfet_01v8_lvt ad=0.1229 pd=1.085 as=0.1824 ps=1.85 w=0.64 l=0.15
X20 a_206_368# a_27_74# VGND.t1 VNB.t0 sky130_fd_pr__nfet_01v8_lvt ad=0.2553 pd=2.17 as=0.1739 ps=1.21 w=0.74 l=0.15
X21 a_731_101# a_206_368# a_561_463# VNB.t10 sky130_fd_pr__nfet_01v8_lvt ad=0.0441 pd=0.63 as=0.07875 ps=0.865 w=0.42 l=0.15
X22 a_1011_424# a_206_368# a_713_458# VNB.t11 sky130_fd_pr__nfet_01v8_lvt ad=0.1181 pd=1.035 as=0.10905 ps=1.025 w=0.55 l=0.15
X23 a_454_503# D.t0 VGND.t0 VNB.t8 sky130_fd_pr__nfet_01v8_lvt ad=0.15563 pd=1.215 as=0.23015 ps=2.1 w=0.42 l=0.15
R0 Q.n0 Q.t0 305.339
R1 Q.t1 Q.n0 279.738
R2 Q.n1 Q.t1 279.738
R3 Q.n1 Q 11.5561
R4 Q.n0 Q 4.44494
R5 Q Q.n1 1.6005
R6 VGND.n1 VGND.t0 315.938
R7 VGND.n8 VGND.t4 257.195
R8 VGND.n27 VGND.n26 214.185
R9 VGND.n9 VGND.n7 211.57
R10 VGND.n4 VGND.n3 211.452
R11 VGND.n3 VGND.t6 67.6369
R12 VGND.n26 VGND.t1 53.514
R13 VGND.n3 VGND.t2 53.0654
R14 VGND.n25 VGND.n24 36.1417
R15 VGND.n20 VGND.n19 36.1417
R16 VGND.n19 VGND.n18 36.1417
R17 VGND.n14 VGND.n13 36.1417
R18 VGND.n13 VGND.n12 36.1417
R19 VGND.n12 VGND.n6 36.1417
R20 VGND.n18 VGND.n4 35.3887
R21 VGND.n7 VGND.t3 31.8755
R22 VGND.n27 VGND.n25 30.4946
R23 VGND.n7 VGND.t5 29.2236
R24 VGND.n20 VGND.n1 24.4711
R25 VGND.n24 VGND.n1 22.9652
R26 VGND.n26 VGND.t7 22.7032
R27 VGND.n14 VGND.n4 18.0711
R28 VGND.n8 VGND.n6 17.3181
R29 VGND.n10 VGND.n6 9.3005
R30 VGND.n12 VGND.n11 9.3005
R31 VGND.n13 VGND.n5 9.3005
R32 VGND.n15 VGND.n14 9.3005
R33 VGND.n16 VGND.n4 9.3005
R34 VGND.n18 VGND.n17 9.3005
R35 VGND.n19 VGND.n2 9.3005
R36 VGND.n21 VGND.n20 9.3005
R37 VGND.n22 VGND.n1 9.3005
R38 VGND.n24 VGND.n23 9.3005
R39 VGND.n25 VGND.n0 9.3005
R40 VGND.n28 VGND.n27 7.19894
R41 VGND.n9 VGND.n8 7.02705
R42 VGND.n10 VGND.n9 0.536227
R43 VGND VGND.n28 0.156997
R44 VGND.n28 VGND.n0 0.150766
R45 VGND.n23 VGND.n0 0.122949
R46 VGND.n23 VGND.n22 0.122949
R47 VGND.n22 VGND.n21 0.122949
R48 VGND.n21 VGND.n2 0.122949
R49 VGND.n17 VGND.n2 0.122949
R50 VGND.n17 VGND.n16 0.122949
R51 VGND.n16 VGND.n15 0.122949
R52 VGND.n15 VGND.n5 0.122949
R53 VGND.n11 VGND.n5 0.122949
R54 VGND.n11 VGND.n10 0.122949
R55 D D.t0 355.692
R56 D.n0 D.t1 291.063
R57 D.n0 D 3.42907
R58 D D.n0 2.52682
R59 CLK.n0 CLK.t1 259.132
R60 CLK.n0 CLK.t0 198.882
R61 CLK CLK.n0 156.934
R62 VPWR.n2 VPWR.t6 840.035
R63 VPWR.n9 VPWR.t3 677.855
R64 VPWR.n17 VPWR.n16 659.098
R65 VPWR.n8 VPWR.n7 332.779
R66 VPWR.n29 VPWR.n1 331.5
R67 VPWR.n16 VPWR.t1 131.333
R68 VPWR.n16 VPWR.t5 45.4599
R69 VPWR.n7 VPWR.t4 43.8979
R70 VPWR.n15 VPWR.n14 36.1417
R71 VPWR.n14 VPWR.n6 36.1417
R72 VPWR.n10 VPWR.n6 36.1417
R73 VPWR.n24 VPWR.n23 36.1417
R74 VPWR.n23 VPWR.n22 36.1417
R75 VPWR.n22 VPWR.n4 36.1417
R76 VPWR.n29 VPWR.n28 35.3887
R77 VPWR.n7 VPWR.t2 35.1791
R78 VPWR.n18 VPWR.n15 33.7992
R79 VPWR.n28 VPWR.n27 31.2225
R80 VPWR.n1 VPWR.t7 26.3844
R81 VPWR.n1 VPWR.t0 26.3844
R82 VPWR.n24 VPWR.n2 23.6596
R83 VPWR.n17 VPWR.n4 19.7527
R84 VPWR.n10 VPWR.n9 15.0593
R85 VPWR.n28 VPWR.n0 9.3005
R86 VPWR.n27 VPWR.n26 9.3005
R87 VPWR.n25 VPWR.n24 9.3005
R88 VPWR.n23 VPWR.n3 9.3005
R89 VPWR.n22 VPWR.n21 9.3005
R90 VPWR.n20 VPWR.n4 9.3005
R91 VPWR.n19 VPWR.n18 9.3005
R92 VPWR.n15 VPWR.n5 9.3005
R93 VPWR.n14 VPWR.n13 9.3005
R94 VPWR.n12 VPWR.n6 9.3005
R95 VPWR.n11 VPWR.n10 9.3005
R96 VPWR.n30 VPWR.n29 8.45673
R97 VPWR.n9 VPWR.n8 7.12294
R98 VPWR.n18 VPWR.n17 3.27161
R99 VPWR.n27 VPWR.n2 1.70717
R100 VPWR.n11 VPWR.n8 0.524748
R101 VPWR VPWR.n30 0.163644
R102 VPWR.n30 VPWR.n0 0.144205
R103 VPWR.n26 VPWR.n0 0.122949
R104 VPWR.n26 VPWR.n25 0.122949
R105 VPWR.n25 VPWR.n3 0.122949
R106 VPWR.n21 VPWR.n3 0.122949
R107 VPWR.n21 VPWR.n20 0.122949
R108 VPWR.n20 VPWR.n19 0.122949
R109 VPWR.n19 VPWR.n5 0.122949
R110 VPWR.n13 VPWR.n5 0.122949
R111 VPWR.n13 VPWR.n12 0.122949
R112 VPWR.n12 VPWR.n11 0.122949
R113 VPB.t0 VPB.t8 633.333
R114 VPB.t5 VPB.t4 515.861
R115 VPB.t7 VPB.t2 360.082
R116 VPB.t11 VPB.t5 319.221
R117 VPB.t3 VPB.t7 316.668
R118 VPB.t8 VPB.t10 273.253
R119 VPB.t10 VPB.t1 273.253
R120 VPB.t2 VPB.t11 273.253
R121 VPB VPB.t9 257.93
R122 VPB.t4 VPB.t6 257.93
R123 VPB.t9 VPB.t0 229.839
R124 VPB.t1 VPB.t3 199.195
R125 VNB.t0 VNB.t8 3071.92
R126 VNB.t5 VNB.t4 2286.61
R127 VNB.t3 VNB.t7 1570.6
R128 VNB.t8 VNB.t1 1524.41
R129 VNB.t11 VNB.t2 1466.67
R130 VNB.t9 VNB.t0 1432.02
R131 VNB.t7 VNB.t11 1177.95
R132 VNB VNB.t9 1143.31
R133 VNB.t4 VNB.t6 1143.31
R134 VNB.t1 VNB.t10 1097.11
R135 VNB.t2 VNB.t5 958.53
R136 VNB.t10 VNB.t3 831.496
C0 a_454_503# D 0.1153f
C1 Q VPWR 0.11977f
C2 a_27_74# VGND 0.77625f
C3 a_454_503# a_561_463# 0.14439f
C4 a_1011_424# a_206_368# 0.29279f
C5 VPB a_713_458# 0.08413f
C6 CLK a_27_74# 0.20893f
C7 a_1210_314# a_27_74# 0.0649f
C8 VPWR VGND 0.1274f
C9 a_561_463# VGND 0.0157f
C10 VPWR CLK 0.01777f
C11 Q VPB 0.01364f
C12 VPWR a_1210_314# 0.18807f
C13 VPB a_454_503# 0.01026f
C14 a_1011_424# a_27_74# 0.08774f
C15 VPB VGND 0.01901f
C16 a_713_458# VGND 0.02548f
C17 VPWR a_1011_424# 0.02994f
C18 CLK VPB 0.0398f
C19 VPB a_1210_314# 0.18221f
C20 Q VGND 0.06867f
C21 VPB a_1011_424# 0.05565f
C22 Q a_1210_314# 0.11821f
C23 a_1011_424# a_713_458# 0.02621f
C24 CLK VGND 0.01715f
C25 a_1210_314# VGND 0.18024f
C26 a_1011_424# VGND 0.08448f
C27 a_1011_424# a_1210_314# 0.30231f
C28 a_206_368# a_27_74# 0.54419f
C29 a_206_368# D 0.24761f
C30 VPWR a_206_368# 0.54604f
C31 a_561_463# a_206_368# 0.18757f
C32 a_27_74# D 0.05673f
C33 VPB a_206_368# 0.28245f
C34 VPWR a_27_74# 0.15897f
C35 a_206_368# a_713_458# 0.21375f
C36 a_561_463# a_27_74# 0.35097f
C37 VPWR D 0.01123f
C38 VPWR a_561_463# 0.03222f
C39 a_454_503# a_206_368# 0.05569f
C40 VPB a_27_74# 0.22737f
C41 a_713_458# a_27_74# 0.27693f
C42 VPB D 0.09818f
C43 a_206_368# VGND 0.09411f
C44 VPWR VPB 0.26584f
C45 VPB a_561_463# 0.10382f
C46 VPWR a_713_458# 0.01891f
C47 a_1210_314# a_206_368# 0.06302f
C48 a_454_503# a_27_74# 0.04602f
C49 a_561_463# a_713_458# 0.22581f
C50 Q VNB 0.14366f
C51 VGND VNB 0.98084f
C52 D VNB 0.29213f
C53 CLK VNB 0.21168f
C54 VPWR VNB 0.76973f
C55 VPB VNB 1.97776f
C56 a_1011_424# VNB 0.1356f
C57 a_1210_314# VNB 0.2091f
C58 a_561_463# VNB 0.12443f
C59 a_713_458# VNB 0.14087f
C60 a_206_368# VNB 0.56488f
C61 a_27_74# VNB 0.45754f
C62 VPB.t6 VNB 0.15337f
C63 VPB.t4 VNB 0.12261f
C64 VPB.t5 VNB 0.13233f
C65 VPB.t11 VNB 0.09388f
C66 VPB.t2 VNB 0.10036f
C67 VPB.t7 VNB 0.10724f
C68 VPB.t3 VNB 0.08174f
C69 VPB.t1 VNB 0.07486f
C70 VPB.t10 VNB 0.0866f
C71 VPB.t8 VNB 0.14366f
C72 VPB.t0 VNB 0.13678f
C73 VPB.t9 VNB 0.07729f
C74 VPWR.n0 VNB 0.0525f
C75 VPWR.t0 VNB 0.01633f
C76 VPWR.t7 VNB 0.01633f
C77 VPWR.n1 VNB 0.03551f
C78 VPWR.t6 VNB 0.04775f
C79 VPWR.n2 VNB 0.0293f
C80 VPWR.n3 VNB 0.04573f
C81 VPWR.n4 VNB 0.01374f
C82 VPWR.n5 VNB 0.04573f
C83 VPWR.n6 VNB 0.01587f
C84 VPWR.t4 VNB 0.01816f
C85 VPWR.t2 VNB 0.01225f
C86 VPWR.n7 VNB 0.04966f
C87 VPWR.n8 VNB 0.15802f
C88 VPWR.t3 VNB 0.02333f
C89 VPWR.n9 VNB 0.07007f
C90 VPWR.n10 VNB 0.01124f
C91 VPWR.n11 VNB 0.18623f
C92 VPWR.n12 VNB 0.04573f
C93 VPWR.n13 VNB 0.04573f
C94 VPWR.n14 VNB 0.01587f
C95 VPWR.n15 VNB 0.01543f
C96 VPWR.t1 VNB 0.01143f
C97 VPWR.n16 VNB 0.0549f
C98 VPWR.n17 VNB 0.02155f
C99 VPWR.n18 VNB 0.01612f
C100 VPWR.n19 VNB 0.04573f
C101 VPWR.n20 VNB 0.04573f
C102 VPWR.n21 VNB 0.04573f
C103 VPWR.n22 VNB 0.01587f
C104 VPWR.n23 VNB 0.01587f
C105 VPWR.n24 VNB 0.01443f
C106 VPWR.n25 VNB 0.04573f
C107 VPWR.n26 VNB 0.04573f
C108 VPWR.n27 VNB 0.01698f
C109 VPWR.n28 VNB 0.015f
C110 VPWR.n29 VNB 0.04699f
C111 VPWR.n30 VNB 0.05758f
C112 CLK.t1 VNB 0.05835f
C113 CLK.t0 VNB 0.03881f
C114 CLK.n0 VNB 0.10601f
C115 D.t1 VNB 0.09349f
C116 D.t0 VNB 0.09926f
C117 D.n0 VNB 0.15186f
C118 VGND.n0 VNB 0.05249f
C119 VGND.t0 VNB 0.03586f
C120 VGND.n1 VNB 0.05765f
C121 VGND.n2 VNB 0.04429f
C122 VGND.t6 VNB 0.01605f
C123 VGND.n3 VNB 0.03786f
C124 VGND.n4 VNB 0.03879f
C125 VGND.n5 VNB 0.04429f
C126 VGND.n6 VNB 0.01136f
C127 VGND.t3 VNB 0.01024f
C128 VGND.n7 VNB 0.03216f
C129 VGND.t4 VNB 0.02491f
C130 VGND.n8 VNB 0.08036f
C131 VGND.n9 VNB 0.11463f
C132 VGND.n10 VNB 0.1812f
C133 VGND.n11 VNB 0.04429f
C134 VGND.n12 VNB 0.01537f
C135 VGND.n13 VNB 0.01537f
C136 VGND.n14 VNB 0.01152f
C137 VGND.n15 VNB 0.04429f
C138 VGND.n16 VNB 0.04429f
C139 VGND.n17 VNB 0.04429f
C140 VGND.n18 VNB 0.01521f
C141 VGND.n19 VNB 0.01537f
C142 VGND.n20 VNB 0.01288f
C143 VGND.n21 VNB 0.04429f
C144 VGND.n22 VNB 0.04429f
C145 VGND.n23 VNB 0.04429f
C146 VGND.n24 VNB 0.01256f
C147 VGND.n25 VNB 0.01417f
C148 VGND.t1 VNB 0.02299f
C149 VGND.n26 VNB 0.03599f
C150 VGND.n27 VNB 0.05294f
C151 VGND.n28 VNB 0.05258f
C152 Q.t0 VNB 0.10387f
C153 Q.n0 VNB 0.12456f
C154 Q.t1 VNB 0.03949f
C155 Q.n1 VNB 0.02241f
.ends

.subckt negedge_detector clk reset comp enable VGND VPWR
Xsky130_fd_sc_hs__o21ba_1_0 sky130_fd_sc_hs__dfxtp_1_1/Q sky130_fd_sc_hs__dfxtp_1_0/Q
+ reset VGND VGND VPWR VPWR sky130_fd_sc_hs__o21ba_1_0/X sky130_fd_sc_hs__o21ba_1_0/a_200_392#
+ sky130_fd_sc_hs__o21ba_1_0/a_116_392# sky130_fd_sc_hs__o21ba_1_0/a_281_244# sky130_fd_sc_hs__o21ba_1_0/a_27_74#
+ nd_o21ba_1
Xsky130_fd_sc_hs__nor2b_1_0 reset comp VGND VGND VPWR VPWR sky130_fd_sc_hs__nor2b_1_0/Y
+ sky130_fd_sc_hs__nor2b_1_0/a_27_112# nd_nor2b_1
Xsky130_fd_sc_hs__nor2b_1_1 sky130_fd_sc_hs__nor2b_1_1/A sky130_fd_sc_hs__dfxtp_1_1/Q
+ VGND VGND VPWR VPWR enable sky130_fd_sc_hs__nor2b_1_1/a_27_112# nd_nor2b_1
Xsky130_fd_sc_hs__clkinv_1_0 clk VGND VGND VPWR VPWR sky130_fd_sc_hs__clkinv_1_0/Y
+ nd_clkinv_1
Xsky130_fd_sc_hs__nor2b_1_2 reset sky130_fd_sc_hs__dfxtp_1_1/Q VGND VGND VPWR VPWR
+ sky130_fd_sc_hs__nor2b_1_2/Y sky130_fd_sc_hs__nor2b_1_2/a_27_112# nd_nor2b_1
Xsky130_fd_sc_hs__dfxtp_1_0 sky130_fd_sc_hs__clkinv_1_0/Y sky130_fd_sc_hs__nor2b_1_0/Y
+ VGND VGND VPWR VPWR sky130_fd_sc_hs__dfxtp_1_0/Q sky130_fd_sc_hs__dfxtp_1_0/a_1011_424#
+ sky130_fd_sc_hs__dfxtp_1_0/a_1210_314# sky130_fd_sc_hs__dfxtp_1_0/a_561_463# sky130_fd_sc_hs__dfxtp_1_0/a_27_74#
+ sky130_fd_sc_hs__dfxtp_1_0/a_206_368# sky130_fd_sc_hs__dfxtp_1_0/a_713_458# nd_dfxtp_1
Xsky130_fd_sc_hs__dfxtp_1_2 clk sky130_fd_sc_hs__nor2b_1_2/Y VGND VGND VPWR VPWR sky130_fd_sc_hs__nor2b_1_1/A
+ sky130_fd_sc_hs__dfxtp_1_2/a_1011_424# sky130_fd_sc_hs__dfxtp_1_2/a_1210_314# sky130_fd_sc_hs__dfxtp_1_2/a_561_463#
+ sky130_fd_sc_hs__dfxtp_1_2/a_27_74# sky130_fd_sc_hs__dfxtp_1_2/a_206_368# sky130_fd_sc_hs__dfxtp_1_2/a_713_458#
+ nd_dfxtp_1
Xsky130_fd_sc_hs__dfxtp_1_1 clk sky130_fd_sc_hs__o21ba_1_0/X VGND VGND VPWR VPWR sky130_fd_sc_hs__dfxtp_1_1/Q
+ sky130_fd_sc_hs__dfxtp_1_1/a_1011_424# sky130_fd_sc_hs__dfxtp_1_1/a_1210_314# sky130_fd_sc_hs__dfxtp_1_1/a_561_463#
+ sky130_fd_sc_hs__dfxtp_1_1/a_27_74# sky130_fd_sc_hs__dfxtp_1_1/a_206_368# sky130_fd_sc_hs__dfxtp_1_1/a_713_458#
+ nd_dfxtp_1
R0 VGND.n25 VGND 9637.55
R1 VGND.n26 VGND 9637.55
R2 VGND VGND 9362.19
R3 VGND VGND.n138 4681.1
R4 VGND.n152 VGND 3028.94
R5 VGND VGND 2753.59
R6 VGND.n151 VGND 1927.51
R7 VGND.n151 VGND.n150 611.778
R8 VGND.n153 VGND.n152 611.778
R9 VGND.n138 VGND.n137 611.778
R10 VGND.n25 VGND.n13 611.778
R11 VGND.n28 VGND.n26 611.778
R12 VGND.n26 VGND 275.36
R13 VGND.n138 VGND 263.885
R14 VGND VGND.n151 252.412
R15 VGND.n152 VGND 252.412
R16 VGND VGND.n25 252.412
R17 VGND.n145 VGND.n139 36.1417
R18 VGND.n40 VGND.n39 36.1417
R19 VGND.n39 VGND.n22 36.1417
R20 VGND.n35 VGND.n22 36.1417
R21 VGND.n46 VGND.n45 36.1417
R22 VGND.n45 VGND.n20 36.1417
R23 VGND.n51 VGND.n18 36.1417
R24 VGND.n60 VGND.n59 36.1417
R25 VGND.n73 VGND.n72 36.1417
R26 VGND.n72 VGND.n71 36.1417
R27 VGND.n71 VGND.n10 36.1417
R28 VGND.n79 VGND.n78 36.1417
R29 VGND.n78 VGND.n77 36.1417
R30 VGND.n84 VGND.n83 36.1417
R31 VGND.n127 VGND.n89 36.1417
R32 VGND.n131 VGND.n89 36.1417
R33 VGND.n132 VGND.n131 36.1417
R34 VGND.n125 VGND.n91 36.1417
R35 VGND.n114 VGND.n113 36.1417
R36 VGND.n115 VGND.n114 36.1417
R37 VGND.n115 VGND.n93 36.1417
R38 VGND.n108 VGND.n107 36.1417
R39 VGND.n109 VGND.n108 36.1417
R40 VGND.n103 VGND.n102 36.1417
R41 VGND.n41 VGND.n20 35.3887
R42 VGND.n77 VGND.n8 35.3887
R43 VGND.n109 VGND.n95 35.3887
R44 VGND.n150 VGND.n149 32.4792
R45 VGND.n53 VGND.n16 30.8711
R46 VGND.n52 VGND.n51 30.4946
R47 VGND.n85 VGND.n84 30.4946
R48 VGND.n102 VGND.n101 30.4946
R49 VGND.n144 VGND.n143 30.1181
R50 VGND.n34 VGND.n33 30.1181
R51 VGND.n58 VGND.n57 30.1181
R52 VGND.n67 VGND.n66 30.1181
R53 VGND.n120 VGND.n119 30.1181
R54 VGND.n29 VGND.n24 28.9887
R55 VGND.n65 VGND.n64 28.9887
R56 VGND.n121 VGND.n91 28.9887
R57 VGND.n133 VGND.n3 28.6123
R58 VGND.n126 VGND.n125 28.2358
R59 VGND.n29 VGND.n28 24.8476
R60 VGND.n64 VGND.n13 24.8476
R61 VGND.n137 VGND.n3 24.8476
R62 VGND.n47 VGND.n46 24.4711
R63 VGND.n79 VGND.n6 24.4711
R64 VGND.n107 VGND.n97 24.4711
R65 VGND.n137 VGND.n4 24.0946
R66 VGND.n150 VGND.n139 23.3417
R67 VGND.n60 VGND.n13 23.3417
R68 VGND.n153 VGND.n1 23.3417
R69 VGND.n47 VGND.n18 22.9652
R70 VGND.n53 VGND.n52 22.9652
R71 VGND.n83 VGND.n6 22.9652
R72 VGND.n85 VGND.n4 22.9652
R73 VGND.n103 VGND.n97 22.9652
R74 VGND.n101 VGND.n1 22.9652
R75 VGND.n143 VGND.n2 20.7064
R76 VGND.n57 VGND.n16 20.7064
R77 VGND.n153 VGND.n2 19.577
R78 VGND.n33 VGND.n24 19.577
R79 VGND.n66 VGND.n65 19.577
R80 VGND.n121 VGND.n120 19.577
R81 VGND.n127 VGND.n126 19.2005
R82 VGND.n133 VGND.n132 18.824
R83 VGND.n41 VGND.n40 18.0711
R84 VGND.n73 VGND.n8 18.0711
R85 VGND.n113 VGND.n95 18.0711
R86 VGND.n145 VGND.n144 17.3181
R87 VGND.n35 VGND.n34 17.3181
R88 VGND.n59 VGND.n58 17.3181
R89 VGND.n67 VGND.n10 17.3181
R90 VGND.n119 VGND.n93 17.3181
R91 VGND.n147 VGND.n139 9.3005
R92 VGND.n146 VGND.n145 9.3005
R93 VGND.n144 VGND.n140 9.3005
R94 VGND.n143 VGND.n142 9.3005
R95 VGND.n141 VGND.n2 9.3005
R96 VGND.n154 VGND.n153 9.3005
R97 VGND.n1 VGND.n0 9.3005
R98 VGND.n101 VGND.n100 9.3005
R99 VGND.n102 VGND.n98 9.3005
R100 VGND.n104 VGND.n103 9.3005
R101 VGND.n105 VGND.n97 9.3005
R102 VGND.n107 VGND.n106 9.3005
R103 VGND.n108 VGND.n96 9.3005
R104 VGND.n110 VGND.n109 9.3005
R105 VGND.n111 VGND.n95 9.3005
R106 VGND.n113 VGND.n112 9.3005
R107 VGND.n114 VGND.n94 9.3005
R108 VGND.n116 VGND.n115 9.3005
R109 VGND.n117 VGND.n93 9.3005
R110 VGND.n119 VGND.n118 9.3005
R111 VGND.n120 VGND.n92 9.3005
R112 VGND.n122 VGND.n121 9.3005
R113 VGND.n123 VGND.n91 9.3005
R114 VGND.n125 VGND.n124 9.3005
R115 VGND.n126 VGND.n90 9.3005
R116 VGND.n128 VGND.n127 9.3005
R117 VGND.n129 VGND.n89 9.3005
R118 VGND.n131 VGND.n130 9.3005
R119 VGND.n132 VGND.n88 9.3005
R120 VGND.n134 VGND.n133 9.3005
R121 VGND.n135 VGND.n3 9.3005
R122 VGND.n137 VGND.n136 9.3005
R123 VGND.n87 VGND.n4 9.3005
R124 VGND.n86 VGND.n85 9.3005
R125 VGND.n84 VGND.n5 9.3005
R126 VGND.n83 VGND.n82 9.3005
R127 VGND.n81 VGND.n6 9.3005
R128 VGND.n80 VGND.n79 9.3005
R129 VGND.n78 VGND.n7 9.3005
R130 VGND.n77 VGND.n76 9.3005
R131 VGND.n75 VGND.n8 9.3005
R132 VGND.n74 VGND.n73 9.3005
R133 VGND.n72 VGND.n9 9.3005
R134 VGND.n71 VGND.n70 9.3005
R135 VGND.n69 VGND.n10 9.3005
R136 VGND.n68 VGND.n67 9.3005
R137 VGND.n66 VGND.n11 9.3005
R138 VGND.n65 VGND.n12 9.3005
R139 VGND.n64 VGND.n63 9.3005
R140 VGND.n62 VGND.n13 9.3005
R141 VGND.n61 VGND.n60 9.3005
R142 VGND.n59 VGND.n14 9.3005
R143 VGND.n58 VGND.n15 9.3005
R144 VGND.n57 VGND.n56 9.3005
R145 VGND.n55 VGND.n16 9.3005
R146 VGND.n54 VGND.n53 9.3005
R147 VGND.n52 VGND.n17 9.3005
R148 VGND.n51 VGND.n50 9.3005
R149 VGND.n49 VGND.n18 9.3005
R150 VGND.n48 VGND.n47 9.3005
R151 VGND.n46 VGND.n19 9.3005
R152 VGND.n45 VGND.n44 9.3005
R153 VGND.n43 VGND.n20 9.3005
R154 VGND.n42 VGND.n41 9.3005
R155 VGND.n40 VGND.n21 9.3005
R156 VGND.n39 VGND.n38 9.3005
R157 VGND.n37 VGND.n22 9.3005
R158 VGND.n36 VGND.n35 9.3005
R159 VGND.n34 VGND.n23 9.3005
R160 VGND.n33 VGND.n32 9.3005
R161 VGND.n31 VGND.n24 9.3005
R162 VGND.n30 VGND.n29 9.3005
R163 VGND.n150 VGND.n148 9.3005
R164 VGND.n99 VGND 8.06316
R165 VGND.n28 VGND.n27 7.22404
R166 VGND.n149 VGND 0.280496
R167 VGND.n147 VGND.n146 0.122949
R168 VGND.n146 VGND.n140 0.122949
R169 VGND.n142 VGND.n140 0.122949
R170 VGND.n142 VGND.n141 0.122949
R171 VGND.n100 VGND.n98 0.122949
R172 VGND.n104 VGND.n98 0.122949
R173 VGND.n105 VGND.n104 0.122949
R174 VGND.n106 VGND.n105 0.122949
R175 VGND.n106 VGND.n96 0.122949
R176 VGND.n110 VGND.n96 0.122949
R177 VGND.n111 VGND.n110 0.122949
R178 VGND.n112 VGND.n111 0.122949
R179 VGND.n112 VGND.n94 0.122949
R180 VGND.n116 VGND.n94 0.122949
R181 VGND.n117 VGND.n116 0.122949
R182 VGND.n118 VGND.n117 0.122949
R183 VGND.n118 VGND.n92 0.122949
R184 VGND.n122 VGND.n92 0.122949
R185 VGND.n123 VGND.n122 0.122949
R186 VGND.n124 VGND.n90 0.122949
R187 VGND.n128 VGND.n90 0.122949
R188 VGND.n129 VGND.n128 0.122949
R189 VGND.n130 VGND.n129 0.122949
R190 VGND.n130 VGND.n88 0.122949
R191 VGND.n134 VGND.n88 0.122949
R192 VGND.n135 VGND.n134 0.122949
R193 VGND.n87 VGND.n86 0.122949
R194 VGND.n86 VGND.n5 0.122949
R195 VGND.n82 VGND.n5 0.122949
R196 VGND.n82 VGND.n81 0.122949
R197 VGND.n81 VGND.n80 0.122949
R198 VGND.n80 VGND.n7 0.122949
R199 VGND.n76 VGND.n7 0.122949
R200 VGND.n76 VGND.n75 0.122949
R201 VGND.n75 VGND.n74 0.122949
R202 VGND.n74 VGND.n9 0.122949
R203 VGND.n70 VGND.n9 0.122949
R204 VGND.n70 VGND.n69 0.122949
R205 VGND.n69 VGND.n68 0.122949
R206 VGND.n68 VGND.n11 0.122949
R207 VGND.n12 VGND.n11 0.122949
R208 VGND.n63 VGND.n12 0.122949
R209 VGND.n61 VGND.n14 0.122949
R210 VGND.n15 VGND.n14 0.122949
R211 VGND.n56 VGND.n15 0.122949
R212 VGND.n56 VGND.n55 0.122949
R213 VGND.n54 VGND.n17 0.122949
R214 VGND.n50 VGND.n17 0.122949
R215 VGND.n50 VGND.n49 0.122949
R216 VGND.n49 VGND.n48 0.122949
R217 VGND.n48 VGND.n19 0.122949
R218 VGND.n44 VGND.n19 0.122949
R219 VGND.n44 VGND.n43 0.122949
R220 VGND.n43 VGND.n42 0.122949
R221 VGND.n42 VGND.n21 0.122949
R222 VGND.n38 VGND.n21 0.122949
R223 VGND.n38 VGND.n37 0.122949
R224 VGND.n37 VGND.n36 0.122949
R225 VGND.n36 VGND.n23 0.122949
R226 VGND.n32 VGND.n23 0.122949
R227 VGND.n32 VGND.n31 0.122949
R228 VGND.n31 VGND.n30 0.122949
R229 VGND.n99 VGND.n0 0.120398
R230 VGND.n149 VGND 0.089033
R231 VGND.n27 VGND 0.0758082
R232 VGND VGND.n148 0.0617245
R233 VGND VGND.n147 0.0617245
R234 VGND.n141 VGND 0.0617245
R235 VGND.n154 VGND 0.0617245
R236 VGND VGND.n0 0.0617245
R237 VGND VGND.n123 0.0617245
R238 VGND.n124 VGND 0.0617245
R239 VGND VGND.n135 0.0617245
R240 VGND.n136 VGND 0.0617245
R241 VGND VGND.n87 0.0617245
R242 VGND.n63 VGND 0.0617245
R243 VGND VGND.n62 0.0617245
R244 VGND VGND.n61 0.0617245
R245 VGND.n55 VGND 0.0617245
R246 VGND VGND.n54 0.0617245
R247 VGND.n30 VGND 0.0617245
R248 VGND.n136 VGND 0.0591735
R249 VGND.n148 VGND 0.0566224
R250 VGND VGND.n154 0.0566224
R251 VGND.n62 VGND 0.0566224
R252 VGND.n27 VGND 0.0485513
R253 VGND.n100 VGND.n99 0.00305102
R254 VPWR VPWR.n5 4290.32
R255 VPWR VPWR.n4 4290.32
R256 VPWR VPWR 4167.74
R257 VPWR VPWR.n6 2083.87
R258 VPWR.n8 VPWR 1348.39
R259 VPWR VPWR 1225.81
R260 VPWR.n7 VPWR 858.066
R261 VPWR.n7 VPWR 198.817
R262 VPWR.n6 VPWR 198.817
R263 VPWR.n5 VPWR 198.817
R264 VPWR.n4 VPWR 198.817
R265 VPWR.n9 VPWR.n8 198.776
R266 VPWR.n4 VPWR 122.582
R267 VPWR.n6 VPWR 117.474
R268 VPWR VPWR.n7 112.367
R269 VPWR.n8 VPWR 112.367
R270 VPWR.n5 VPWR 112.367
R271 VPWR.n45 VPWR.n44 43.8059
R272 VPWR.n56 VPWR.n55 36.1417
R273 VPWR.n55 VPWR.n41 36.1417
R274 VPWR.n51 VPWR.n41 36.1417
R275 VPWR.n63 VPWR.n62 36.1417
R276 VPWR.n62 VPWR.n61 36.1417
R277 VPWR.n61 VPWR.n39 36.1417
R278 VPWR.n73 VPWR.n35 36.1417
R279 VPWR.n69 VPWR.n35 36.1417
R280 VPWR.n69 VPWR.n68 36.1417
R281 VPWR.n68 VPWR.n67 36.1417
R282 VPWR.n80 VPWR.n32 36.1417
R283 VPWR.n76 VPWR.n75 36.1417
R284 VPWR.n89 VPWR.n88 36.1417
R285 VPWR.n88 VPWR.n87 36.1417
R286 VPWR.n87 VPWR.n29 36.1417
R287 VPWR.n95 VPWR.n25 36.1417
R288 VPWR.n95 VPWR.n94 36.1417
R289 VPWR.n94 VPWR.n93 36.1417
R290 VPWR.n106 VPWR.n105 36.1417
R291 VPWR.n101 VPWR.n23 36.1417
R292 VPWR.n101 VPWR.n100 36.1417
R293 VPWR.n111 VPWR.n21 36.1417
R294 VPWR.n114 VPWR.n113 36.1417
R295 VPWR.n127 VPWR.n126 36.1417
R296 VPWR.n126 VPWR.n125 36.1417
R297 VPWR.n125 VPWR.n15 36.1417
R298 VPWR.n133 VPWR.n11 36.1417
R299 VPWR.n133 VPWR.n132 36.1417
R300 VPWR.n132 VPWR.n131 36.1417
R301 VPWR.n145 VPWR.n144 36.1417
R302 VPWR.n144 VPWR.n143 36.1417
R303 VPWR.n139 VPWR.n3 36.1417
R304 VPWR.n139 VPWR.n138 36.1417
R305 VPWR.n151 VPWR.n150 36.1417
R306 VPWR.n105 VPWR.n23 35.3887
R307 VPWR.n76 VPWR.n32 34.6358
R308 VPWR.n143 VPWR.n3 34.6358
R309 VPWR.n153 VPWR.n151 34.6358
R310 VPWR.n57 VPWR.n56 33.7992
R311 VPWR.n89 VPWR.n27 33.7992
R312 VPWR.n127 VPWR.n13 33.7992
R313 VPWR.n153 VPWR.n152 32.984
R314 VPWR.n50 VPWR.n49 32.377
R315 VPWR.n83 VPWR.n82 32.377
R316 VPWR.n121 VPWR.n120 32.377
R317 VPWR.n74 VPWR.n73 32.0005
R318 VPWR.n145 VPWR.n1 32.0005
R319 VPWR.n67 VPWR.n37 31.2225
R320 VPWR.n100 VPWR.n99 31.2225
R321 VPWR.n138 VPWR.n137 31.2225
R322 VPWR.n45 VPWR.n43 28.6123
R323 VPWR.n81 VPWR.n80 28.6123
R324 VPWR.n119 VPWR.n118 28.6123
R325 VPWR.n107 VPWR.n106 28.2358
R326 VPWR.n113 VPWR.n112 26.7299
R327 VPWR.n118 VPWR.n18 26.7299
R328 VPWR.n63 VPWR.n37 25.3663
R329 VPWR.n99 VPWR.n25 25.3663
R330 VPWR.n137 VPWR.n11 25.3663
R331 VPWR.n57 VPWR.n39 23.0238
R332 VPWR.n93 VPWR.n27 23.0238
R333 VPWR.n131 VPWR.n13 23.0238
R334 VPWR.n112 VPWR.n111 20.7064
R335 VPWR.n114 VPWR.n18 20.7064
R336 VPWR.n107 VPWR.n21 19.2005
R337 VPWR.n49 VPWR.n43 18.824
R338 VPWR.n82 VPWR.n81 18.824
R339 VPWR.n120 VPWR.n119 18.824
R340 VPWR.n75 VPWR.n74 15.4358
R341 VPWR.n150 VPWR.n1 15.4358
R342 VPWR.n51 VPWR.n50 15.0593
R343 VPWR.n83 VPWR.n29 15.0593
R344 VPWR.n121 VPWR.n15 15.0593
R345 VPWR.n154 VPWR.n153 9.3005
R346 VPWR.n151 VPWR.n0 9.3005
R347 VPWR.n150 VPWR.n149 9.3005
R348 VPWR.n147 VPWR.n1 9.3005
R349 VPWR.n146 VPWR.n145 9.3005
R350 VPWR.n144 VPWR.n2 9.3005
R351 VPWR.n143 VPWR.n142 9.3005
R352 VPWR.n141 VPWR.n3 9.3005
R353 VPWR.n140 VPWR.n139 9.3005
R354 VPWR.n138 VPWR.n10 9.3005
R355 VPWR.n137 VPWR.n136 9.3005
R356 VPWR.n135 VPWR.n11 9.3005
R357 VPWR.n134 VPWR.n133 9.3005
R358 VPWR.n132 VPWR.n12 9.3005
R359 VPWR.n131 VPWR.n130 9.3005
R360 VPWR.n129 VPWR.n13 9.3005
R361 VPWR.n128 VPWR.n127 9.3005
R362 VPWR.n126 VPWR.n14 9.3005
R363 VPWR.n125 VPWR.n124 9.3005
R364 VPWR.n123 VPWR.n15 9.3005
R365 VPWR.n122 VPWR.n121 9.3005
R366 VPWR.n120 VPWR.n16 9.3005
R367 VPWR.n119 VPWR.n17 9.3005
R368 VPWR.n118 VPWR.n117 9.3005
R369 VPWR.n116 VPWR.n18 9.3005
R370 VPWR.n115 VPWR.n114 9.3005
R371 VPWR.n113 VPWR.n19 9.3005
R372 VPWR.n112 VPWR.n20 9.3005
R373 VPWR.n111 VPWR.n110 9.3005
R374 VPWR.n109 VPWR.n21 9.3005
R375 VPWR.n108 VPWR.n107 9.3005
R376 VPWR.n106 VPWR.n22 9.3005
R377 VPWR.n105 VPWR.n104 9.3005
R378 VPWR.n103 VPWR.n23 9.3005
R379 VPWR.n102 VPWR.n101 9.3005
R380 VPWR.n100 VPWR.n24 9.3005
R381 VPWR.n99 VPWR.n98 9.3005
R382 VPWR.n97 VPWR.n25 9.3005
R383 VPWR.n96 VPWR.n95 9.3005
R384 VPWR.n94 VPWR.n26 9.3005
R385 VPWR.n93 VPWR.n92 9.3005
R386 VPWR.n91 VPWR.n27 9.3005
R387 VPWR.n90 VPWR.n89 9.3005
R388 VPWR.n88 VPWR.n28 9.3005
R389 VPWR.n87 VPWR.n86 9.3005
R390 VPWR.n85 VPWR.n29 9.3005
R391 VPWR.n84 VPWR.n83 9.3005
R392 VPWR.n82 VPWR.n30 9.3005
R393 VPWR.n81 VPWR.n31 9.3005
R394 VPWR.n80 VPWR.n79 9.3005
R395 VPWR.n78 VPWR.n32 9.3005
R396 VPWR.n77 VPWR.n76 9.3005
R397 VPWR.n75 VPWR.n33 9.3005
R398 VPWR.n74 VPWR.n34 9.3005
R399 VPWR.n73 VPWR.n72 9.3005
R400 VPWR.n71 VPWR.n35 9.3005
R401 VPWR.n70 VPWR.n69 9.3005
R402 VPWR.n68 VPWR.n36 9.3005
R403 VPWR.n67 VPWR.n66 9.3005
R404 VPWR.n65 VPWR.n37 9.3005
R405 VPWR.n64 VPWR.n63 9.3005
R406 VPWR.n62 VPWR.n38 9.3005
R407 VPWR.n61 VPWR.n60 9.3005
R408 VPWR.n59 VPWR.n39 9.3005
R409 VPWR.n58 VPWR.n57 9.3005
R410 VPWR.n56 VPWR.n40 9.3005
R411 VPWR.n55 VPWR.n54 9.3005
R412 VPWR.n53 VPWR.n41 9.3005
R413 VPWR.n52 VPWR.n51 9.3005
R414 VPWR.n50 VPWR.n42 9.3005
R415 VPWR.n49 VPWR.n48 9.3005
R416 VPWR.n47 VPWR.n43 9.3005
R417 VPWR.n46 VPWR.n45 9.3005
R418 VPWR.n148 VPWR 8.11375
R419 VPWR.n152 VPWR 0.2714
R420 VPWR.n142 VPWR.n9 0.153554
R421 VPWR.n149 VPWR.n147 0.122949
R422 VPWR.n147 VPWR.n146 0.122949
R423 VPWR.n146 VPWR.n2 0.122949
R424 VPWR.n141 VPWR.n140 0.122949
R425 VPWR.n140 VPWR.n10 0.122949
R426 VPWR.n136 VPWR.n10 0.122949
R427 VPWR.n136 VPWR.n135 0.122949
R428 VPWR.n135 VPWR.n134 0.122949
R429 VPWR.n134 VPWR.n12 0.122949
R430 VPWR.n130 VPWR.n12 0.122949
R431 VPWR.n130 VPWR.n129 0.122949
R432 VPWR.n129 VPWR.n128 0.122949
R433 VPWR.n128 VPWR.n14 0.122949
R434 VPWR.n124 VPWR.n14 0.122949
R435 VPWR.n124 VPWR.n123 0.122949
R436 VPWR.n123 VPWR.n122 0.122949
R437 VPWR.n122 VPWR.n16 0.122949
R438 VPWR.n17 VPWR.n16 0.122949
R439 VPWR.n117 VPWR.n17 0.122949
R440 VPWR.n116 VPWR.n115 0.122949
R441 VPWR.n115 VPWR.n19 0.122949
R442 VPWR.n20 VPWR.n19 0.122949
R443 VPWR.n110 VPWR.n20 0.122949
R444 VPWR.n110 VPWR.n109 0.122949
R445 VPWR.n109 VPWR.n108 0.122949
R446 VPWR.n108 VPWR.n22 0.122949
R447 VPWR.n103 VPWR.n102 0.122949
R448 VPWR.n102 VPWR.n24 0.122949
R449 VPWR.n98 VPWR.n24 0.122949
R450 VPWR.n98 VPWR.n97 0.122949
R451 VPWR.n97 VPWR.n96 0.122949
R452 VPWR.n96 VPWR.n26 0.122949
R453 VPWR.n92 VPWR.n26 0.122949
R454 VPWR.n92 VPWR.n91 0.122949
R455 VPWR.n91 VPWR.n90 0.122949
R456 VPWR.n90 VPWR.n28 0.122949
R457 VPWR.n86 VPWR.n28 0.122949
R458 VPWR.n86 VPWR.n85 0.122949
R459 VPWR.n85 VPWR.n84 0.122949
R460 VPWR.n84 VPWR.n30 0.122949
R461 VPWR.n31 VPWR.n30 0.122949
R462 VPWR.n79 VPWR.n31 0.122949
R463 VPWR.n77 VPWR.n33 0.122949
R464 VPWR.n34 VPWR.n33 0.122949
R465 VPWR.n72 VPWR.n34 0.122949
R466 VPWR.n72 VPWR.n71 0.122949
R467 VPWR.n70 VPWR.n36 0.122949
R468 VPWR.n66 VPWR.n36 0.122949
R469 VPWR.n66 VPWR.n65 0.122949
R470 VPWR.n65 VPWR.n64 0.122949
R471 VPWR.n64 VPWR.n38 0.122949
R472 VPWR.n60 VPWR.n38 0.122949
R473 VPWR.n60 VPWR.n59 0.122949
R474 VPWR.n59 VPWR.n58 0.122949
R475 VPWR.n58 VPWR.n40 0.122949
R476 VPWR.n54 VPWR.n40 0.122949
R477 VPWR.n54 VPWR.n53 0.122949
R478 VPWR.n53 VPWR.n52 0.122949
R479 VPWR.n52 VPWR.n42 0.122949
R480 VPWR.n48 VPWR.n42 0.122949
R481 VPWR.n48 VPWR.n47 0.122949
R482 VPWR.n47 VPWR.n46 0.122949
R483 VPWR.n149 VPWR.n148 0.11402
R484 VPWR.n152 VPWR 0.0980538
R485 VPWR.n44 VPWR 0.0729259
R486 VPWR.n154 VPWR 0.0617245
R487 VPWR VPWR.n0 0.0617245
R488 VPWR VPWR.n2 0.0617245
R489 VPWR.n142 VPWR 0.0617245
R490 VPWR VPWR.n141 0.0617245
R491 VPWR.n117 VPWR 0.0617245
R492 VPWR VPWR.n116 0.0617245
R493 VPWR VPWR.n22 0.0617245
R494 VPWR.n104 VPWR 0.0617245
R495 VPWR VPWR.n103 0.0617245
R496 VPWR.n79 VPWR 0.0617245
R497 VPWR VPWR.n78 0.0617245
R498 VPWR VPWR.n77 0.0617245
R499 VPWR.n71 VPWR 0.0617245
R500 VPWR VPWR.n70 0.0617245
R501 VPWR.n46 VPWR 0.0617245
R502 VPWR.n104 VPWR 0.0591735
R503 VPWR VPWR.n154 0.0566224
R504 VPWR.n142 VPWR 0.0566224
R505 VPWR.n78 VPWR 0.0566224
R506 VPWR.n44 VPWR 0.0514526
R507 VPWR.n9 VPWR 0.0337031
R508 VPWR.n148 VPWR.n0 0.00942857
R509 reset.n2 reset.n0 283.113
R510 reset.n11 reset.n9 283.113
R511 reset.n6 reset.n4 240.732
R512 reset.n2 reset.n1 175.736
R513 reset.n11 reset.n10 175.736
R514 reset.n3 reset.n2 154.327
R515 reset.n12 reset.n11 152.97
R516 reset.n7 reset.n6 152
R517 reset.n6 reset.n5 147.814
R518 reset.n8 reset.n3 25.2177
R519 reset.n13 reset.n12 23.3894
R520 reset.n8 reset.n7 21.4776
R521 reset.n7 reset 6.78838
R522 reset.n12 reset 5.81868
R523 reset.n3 reset 4.46111
R524 reset.n14 reset.n13 3.53569
R525 reset.n13 reset.n8 2.44338
R526 reset.n14 reset 0.276625
R527 reset.n14 reset 0.0525
R528 reset reset.n14 0.0235104
R529 comp.n2 comp.n0 219.846
R530 comp.n3 comp.n2 213.974
R531 comp.n2 comp.n1 128.288
R532 comp.n3 comp 14.6307
R533 comp comp.n3 5.4308
R534 clk.n2 clk.n0 259.132
R535 clk.n6 clk.n4 259.132
R536 clk.n2 clk.n1 198.882
R537 clk.n6 clk.n5 198.882
R538 clk.n13 clk.n11 189.855
R539 clk.n13 clk.n12 189.855
R540 clk clk.n18 156.294
R541 clk clk.n14 155.76
R542 clk.n3 clk.n2 152.534
R543 clk.n7 clk.n6 152.4
R544 clk.n16 clk.n15 152
R545 clk.n18 clk.n17 121.877
R546 clk.n8 clk.n3 26.8948
R547 clk.n18 clk.n16 26.0132
R548 clk.n16 clk.n14 26.0132
R549 clk.n8 clk.n7 21.0177
R550 clk.n10 clk.n9 17.5762
R551 clk.n14 clk.n13 12.6243
R552 clk.n9 clk.n8 11.1273
R553 clk.n7 clk 4.53383
R554 clk.n3 clk 4.4005
R555 clk.n15 clk 3.14971
R556 clk.n15 clk.n10 2.4386
R557 clk clk.n10 1.93066
R558 clk.n9 clk 0.0998409
R559 enable.n2 enable 806.65
R560 enable.n3 enable.n2 803.014
R561 enable.n2 enable.n0 585
R562 enable.n1 enable 14.2633
R563 enable enable.n3 9.74595
R564 enable enable.n1 8.29141
R565 enable enable.n0 2.32777
R566 enable.n3 enable 1.01868
R567 enable.n1 enable.n0 0.145955
C0 VPWR sky130_fd_sc_hs__nor2b_1_2/Y 0.12134f
C1 sky130_fd_sc_hs__dfxtp_1_2/a_206_368# sky130_fd_sc_hs__dfxtp_1_1/Q 0.0364f
C2 sky130_fd_sc_hs__dfxtp_1_0/a_27_74# VPWR 0.08708f
C3 sky130_fd_sc_hs__dfxtp_1_1/Q sky130_fd_sc_hs__nor2b_1_2/a_27_112# 0.0651f
C4 VPWR sky130_fd_sc_hs__clkinv_1_0/Y 0.14736f
C5 sky130_fd_sc_hs__dfxtp_1_1/a_206_368# sky130_fd_sc_hs__o21ba_1_0/X 0.04325f
C6 reset clk 0.15337f
C7 reset sky130_fd_sc_hs__o21ba_1_0/a_200_392# 0.02084f
C8 reset sky130_fd_sc_hs__dfxtp_1_0/a_206_368# 0.02301f
C9 sky130_fd_sc_hs__o21ba_1_0/a_200_392# clk 0.03975f
C10 clk sky130_fd_sc_hs__dfxtp_1_0/a_206_368# 0.02791f
C11 sky130_fd_sc_hs__o21ba_1_0/X sky130_fd_sc_hs__dfxtp_1_0/Q 0.01018f
C12 sky130_fd_sc_hs__dfxtp_1_1/Q sky130_fd_sc_hs__o21ba_1_0/X 0.10032f
C13 reset sky130_fd_sc_hs__dfxtp_1_0/a_1011_424# 0.01464f
C14 sky130_fd_sc_hs__dfxtp_1_1/Q sky130_fd_sc_hs__nor2b_1_1/a_27_112# 0.03855f
C15 VPWR sky130_fd_sc_hs__dfxtp_1_0/Q 0.24896f
C16 sky130_fd_sc_hs__dfxtp_1_1/Q VPWR 0.24491f
C17 sky130_fd_sc_hs__o21ba_1_0/a_116_392# sky130_fd_sc_hs__dfxtp_1_0/Q 0.01049f
C18 sky130_fd_sc_hs__dfxtp_1_1/a_27_74# sky130_fd_sc_hs__o21ba_1_0/X 0.03722f
C19 sky130_fd_sc_hs__dfxtp_1_1/Q sky130_fd_sc_hs__nor2b_1_1/A 0.09053f
C20 sky130_fd_sc_hs__nor2b_1_0/a_27_112# sky130_fd_sc_hs__clkinv_1_0/Y 0.06142f
C21 sky130_fd_sc_hs__dfxtp_1_0/a_27_74# sky130_fd_sc_hs__nor2b_1_0/Y 0.03841f
C22 sky130_fd_sc_hs__nor2b_1_0/Y sky130_fd_sc_hs__clkinv_1_0/Y 0.16626f
C23 reset comp 0.09567f
C24 VPWR sky130_fd_sc_hs__dfxtp_1_1/a_1210_314# 0.01062f
C25 comp clk 0.03645f
C26 VPWR sky130_fd_sc_hs__dfxtp_1_1/a_27_74# 0.08327f
C27 sky130_fd_sc_hs__dfxtp_1_2/a_206_368# clk 0.01977f
C28 sky130_fd_sc_hs__nor2b_1_2/a_27_112# reset 0.0242f
C29 sky130_fd_sc_hs__nor2b_1_2/a_27_112# clk 0.04368f
C30 sky130_fd_sc_hs__nor2b_1_1/A sky130_fd_sc_hs__dfxtp_1_2/a_1210_314# 0.01088f
C31 sky130_fd_sc_hs__dfxtp_1_2/a_713_458# sky130_fd_sc_hs__dfxtp_1_1/Q 0.01926f
C32 sky130_fd_sc_hs__dfxtp_1_1/Q sky130_fd_sc_hs__o21ba_1_0/a_281_244# 0.02589f
C33 sky130_fd_sc_hs__o21ba_1_0/X clk 0.18652f
C34 sky130_fd_sc_hs__o21ba_1_0/a_200_392# sky130_fd_sc_hs__o21ba_1_0/X 0.01317f
C35 sky130_fd_sc_hs__dfxtp_1_0/a_27_74# sky130_fd_sc_hs__clkinv_1_0/Y 0.04836f
C36 sky130_fd_sc_hs__dfxtp_1_2/a_27_74# sky130_fd_sc_hs__nor2b_1_2/Y 0.1428f
C37 sky130_fd_sc_hs__dfxtp_1_1/Q sky130_fd_sc_hs__nor2b_1_2/Y 0.09961f
C38 reset VPWR 0.0834f
C39 sky130_fd_sc_hs__o21ba_1_0/a_27_74# sky130_fd_sc_hs__dfxtp_1_0/Q 0.05105f
C40 sky130_fd_sc_hs__dfxtp_1_1/Q sky130_fd_sc_hs__o21ba_1_0/a_27_74# 0.058f
C41 VPWR clk 1.40837f
C42 reset sky130_fd_sc_hs__dfxtp_1_0/a_713_458# 0.01529f
C43 sky130_fd_sc_hs__dfxtp_1_1/Q sky130_fd_sc_hs__dfxtp_1_2/a_561_463# 0.01833f
C44 VPWR comp 0.02305f
C45 reset sky130_fd_sc_hs__dfxtp_1_0/a_561_463# 0.01088f
C46 enable VPWR 0.03619f
C47 sky130_fd_sc_hs__dfxtp_1_1/a_1011_424# sky130_fd_sc_hs__dfxtp_1_1/Q 0.02742f
C48 reset sky130_fd_sc_hs__nor2b_1_0/a_27_112# 0.02645f
C49 enable sky130_fd_sc_hs__nor2b_1_1/A 0.04547f
C50 sky130_fd_sc_hs__nor2b_1_0/a_27_112# clk 0.01122f
C51 reset sky130_fd_sc_hs__nor2b_1_0/Y 0.04673f
C52 sky130_fd_sc_hs__nor2b_1_0/Y clk 0.09437f
C53 reset sky130_fd_sc_hs__o21ba_1_0/a_281_244# 0.03655f
C54 sky130_fd_sc_hs__dfxtp_1_1/Q sky130_fd_sc_hs__dfxtp_1_1/a_561_463# 0.0179f
C55 sky130_fd_sc_hs__nor2b_1_0/Y sky130_fd_sc_hs__dfxtp_1_0/a_206_368# 0.04396f
C56 sky130_fd_sc_hs__dfxtp_1_1/a_206_368# sky130_fd_sc_hs__dfxtp_1_1/Q 0.03512f
C57 sky130_fd_sc_hs__o21ba_1_0/a_281_244# clk 0.01142f
C58 sky130_fd_sc_hs__dfxtp_1_1/Q sky130_fd_sc_hs__dfxtp_1_2/a_27_74# 0.08608f
C59 sky130_fd_sc_hs__nor2b_1_2/a_27_112# VPWR 0.0398f
C60 sky130_fd_sc_hs__dfxtp_1_1/Q sky130_fd_sc_hs__dfxtp_1_0/Q 0.13086f
C61 sky130_fd_sc_hs__dfxtp_1_0/a_1210_314# sky130_fd_sc_hs__dfxtp_1_0/Q 0.01169f
C62 sky130_fd_sc_hs__dfxtp_1_1/Q sky130_fd_sc_hs__dfxtp_1_0/a_1210_314# 0.03557f
C63 clk sky130_fd_sc_hs__nor2b_1_2/Y 0.16335f
C64 sky130_fd_sc_hs__dfxtp_1_1/Q sky130_fd_sc_hs__dfxtp_1_1/a_1210_314# 0.04616f
C65 sky130_fd_sc_hs__dfxtp_1_1/a_713_458# sky130_fd_sc_hs__dfxtp_1_1/Q 0.0191f
C66 sky130_fd_sc_hs__dfxtp_1_1/Q sky130_fd_sc_hs__dfxtp_1_1/a_27_74# 0.08882f
C67 sky130_fd_sc_hs__nor2b_1_0/a_27_112# comp 0.03245f
C68 VPWR sky130_fd_sc_hs__o21ba_1_0/X 0.24243f
C69 VPWR sky130_fd_sc_hs__nor2b_1_1/a_27_112# 0.03693f
C70 sky130_fd_sc_hs__nor2b_1_1/a_27_112# sky130_fd_sc_hs__nor2b_1_1/A 0.07364f
C71 sky130_fd_sc_hs__dfxtp_1_0/a_27_74# reset 0.04293f
C72 sky130_fd_sc_hs__dfxtp_1_0/a_27_74# clk 0.01511f
C73 reset sky130_fd_sc_hs__clkinv_1_0/Y 0.11385f
C74 VPWR sky130_fd_sc_hs__nor2b_1_1/A 0.27171f
C75 sky130_fd_sc_hs__dfxtp_1_1/Q sky130_fd_sc_hs__dfxtp_1_2/a_1210_314# 0.04231f
C76 clk sky130_fd_sc_hs__clkinv_1_0/Y 0.10252f
C77 sky130_fd_sc_hs__dfxtp_1_1/Q sky130_fd_sc_hs__dfxtp_1_2/a_1011_424# 0.02662f
C78 sky130_fd_sc_hs__dfxtp_1_1/a_1011_424# clk 0.01207f
C79 sky130_fd_sc_hs__dfxtp_1_2/a_206_368# sky130_fd_sc_hs__nor2b_1_2/Y 0.04656f
C80 sky130_fd_sc_hs__dfxtp_1_1/a_561_463# clk 0.01595f
C81 sky130_fd_sc_hs__dfxtp_1_1/a_206_368# clk 0.04412f
C82 sky130_fd_sc_hs__dfxtp_1_2/a_27_74# clk 0.0583f
C83 reset sky130_fd_sc_hs__dfxtp_1_0/Q 0.02663f
C84 sky130_fd_sc_hs__dfxtp_1_1/Q reset 0.79819f
C85 reset sky130_fd_sc_hs__dfxtp_1_0/a_1210_314# 0.01684f
C86 clk sky130_fd_sc_hs__dfxtp_1_0/Q 0.05334f
C87 sky130_fd_sc_hs__dfxtp_1_1/Q clk 0.21002f
C88 sky130_fd_sc_hs__o21ba_1_0/a_200_392# sky130_fd_sc_hs__dfxtp_1_0/Q 0.06069f
C89 sky130_fd_sc_hs__dfxtp_1_1/Q sky130_fd_sc_hs__o21ba_1_0/a_200_392# 0.03043f
C90 sky130_fd_sc_hs__dfxtp_1_0/a_1210_314# clk 0.01392f
C91 comp sky130_fd_sc_hs__clkinv_1_0/Y 0.07438f
C92 VPWR sky130_fd_sc_hs__nor2b_1_0/a_27_112# 0.04684f
C93 VPWR sky130_fd_sc_hs__nor2b_1_0/Y 0.24275f
C94 reset sky130_fd_sc_hs__dfxtp_1_1/a_27_74# 0.01866f
C95 sky130_fd_sc_hs__dfxtp_1_1/a_1210_314# clk 0.0174f
C96 sky130_fd_sc_hs__dfxtp_1_1/a_27_74# clk 0.06373f
C97 clk.n2 VGND 0.01541f
C98 clk.n3 VGND 0.06104f
C99 clk.n6 VGND 0.0154f
C100 clk.n7 VGND 0.02607f
C101 clk.n8 VGND 0.49119f
C102 clk.n9 VGND 0.22555f
C103 clk.n13 VGND 0.01022f
C104 clk.n14 VGND 0.01071f
C105 clk.n16 VGND 0.01439f
C106 clk.n18 VGND 0.01548f
C107 comp.n0 VGND 0.01344f
C108 comp.n2 VGND 0.0379f
C109 comp.n3 VGND 0.027f
C110 reset.n0 VGND 0.01323f
C111 reset.n2 VGND 0.02111f
C112 reset.n3 VGND 0.07997f
C113 reset.n4 VGND 0.01027f
C114 reset.n6 VGND 0.01776f
C115 reset.n7 VGND 0.03339f
C116 reset.n8 VGND 0.60249f
C117 reset.n9 VGND 0.01323f
C118 reset.n11 VGND 0.02105f
C119 reset.n12 VGND 0.05517f
C120 reset.n13 VGND 0.36413f
C121 reset.n14 VGND 0.08873f
C122 VPWR.n4 VGND 0.01431f
C123 VPWR.n5 VGND 0.01428f
C124 VGND.n25 VGND 0.02545f
C125 VGND.n26 VGND 0.02551f
C126 VGND.n138 VGND 0.01279f
C127 sky130_fd_sc_hs__dfxtp_1_1/a_27_74# VGND 0.06306f
C128 sky130_fd_sc_hs__nor2b_1_1/A VGND 0.14508f
C129 sky130_fd_sc_hs__dfxtp_1_2/a_27_74# VGND 0.02831f
C130 sky130_fd_sc_hs__dfxtp_1_0/Q VGND -0.05248f
C131 sky130_fd_sc_hs__nor2b_1_0/Y VGND 0.0182f
C132 sky130_fd_sc_hs__dfxtp_1_0/a_27_74# VGND 0.07392f
C133 sky130_fd_sc_hs__nor2b_1_2/a_27_112# VGND 0.02234f
C134 sky130_fd_sc_hs__clkinv_1_0/Y VGND 0.15578f
C135 clk VGND 2.06946f
C136 enable VGND 0.18347f
C137 sky130_fd_sc_hs__nor2b_1_1/a_27_112# VGND 0.0217f
C138 comp VGND 0.3711f
C139 VPWR VGND -2.62962f
C140 reset VGND 3.1364f
C141 sky130_fd_sc_hs__nor2b_1_0/a_27_112# VGND 0.02808f
C142 sky130_fd_sc_hs__o21ba_1_0/X VGND 0.02856f
C143 sky130_fd_sc_hs__dfxtp_1_1/Q VGND 1.88488f
.ends
