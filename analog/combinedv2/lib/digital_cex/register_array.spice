.subckt sky130_fd_sc_hs_ra__nor2_1 A B VGND VNB VPB VPWR Y
X0 VPWR A a_116_368# VPB sky130_fd_pr__pfet_01v8 w=1.12e+06u l=150000u
X1 VGND A Y VNB sky130_fd_pr__nfet_01v8_lvt w=740000u l=150000u
X2 Y B VGND VNB sky130_fd_pr__nfet_01v8_lvt w=740000u l=150000u
X3 a_116_368# B Y VPB sky130_fd_pr__pfet_01v8 w=1.12e+06u l=150000u
.ends

.subckt sky130_fd_sc_hs_ra__mux2i_1 A0 A1 S VGND VNB VPB VPWR Y
X0 a_426_74# A0 Y VNB sky130_fd_pr__nfet_01v8_lvt w=740000u l=150000u
X1 VGND a_114_74# a_426_74# VNB sky130_fd_pr__nfet_01v8_lvt w=740000u l=150000u
X2 VPWR S a_114_74# VPB sky130_fd_pr__pfet_01v8 w=840000u l=150000u
X3 a_223_368# A0 Y VPB sky130_fd_pr__pfet_01v8 w=1.12e+06u l=150000u
X4 a_223_368# S VPWR VPB sky130_fd_pr__pfet_01v8 w=1.12e+06u l=150000u
X5 Y A1 a_225_74# VNB sky130_fd_pr__nfet_01v8_lvt w=740000u l=150000u
X6 Y A1 a_399_368# VPB sky130_fd_pr__pfet_01v8 w=1.12e+06u l=150000u
X7 VPWR a_114_74# a_399_368# VPB sky130_fd_pr__pfet_01v8 w=1.12e+06u l=150000u
X8 a_225_74# S VGND VNB sky130_fd_pr__nfet_01v8_lvt w=740000u l=150000u
X9 VGND S a_114_74# VNB sky130_fd_pr__nfet_01v8_lvt w=550000u l=150000u
.ends

.subckt sky130_fd_sc_hs_ra__dfxtp_1 CLK D VGND VNB VPB VPWR Q
X0 VPWR CLK a_27_74# VPB sky130_fd_pr__pfet_01v8 ad=0.168 pd=1.42 as=0.3304 ps=2.83 w=1.12 l=0.15
X1 a_668_503# a_27_74# a_561_463# VPB sky130_fd_pr__pfet_01v8 ad=0.0504 pd=0.66 as=0.09835 ps=1.005 w=0.42 l=0.15
X2 Q a_1210_314# VPWR VPB sky130_fd_pr__pfet_01v8 ad=0.3304 pd=2.83 as=0.1862 ps=1.475 w=1.12 l=0.15
X3 a_454_503# D VPWR VPB sky130_fd_pr__pfet_01v8 ad=0.09835 pd=1.005 as=0.2972 ps=2.41 w=0.42 l=0.15
X4 VPWR a_1011_424# a_1210_314# VPB sky130_fd_pr__pfet_01v8 ad=0.1862 pd=1.475 as=0.2478 ps=2.27 w=0.84 l=0.15
X5 VGND CLK a_27_74# VNB sky130_fd_pr__nfet_01v8_lvt ad=0.1739 pd=1.21 as=0.2109 ps=2.05 w=0.74 l=0.15
X6 a_1118_508# a_206_368# a_1011_424# VPB sky130_fd_pr__pfet_01v8 ad=0.09975 pd=0.895 as=0.1428 ps=1.225 w=0.42 l=0.15
X7 VGND a_1210_314# a_1168_124# VNB sky130_fd_pr__nfet_01v8_lvt ad=0.1197 pd=1.41 as=0.05565 ps=0.685 w=0.42 l=0.15
X8 a_713_458# a_561_463# VGND VNB sky130_fd_pr__nfet_01v8_lvt ad=0.10905 pd=1.025 as=0.1648 ps=1.245 w=0.55 l=0.15
X9 VGND a_713_458# a_731_101# VNB sky130_fd_pr__nfet_01v8_lvt ad=0.1648 pd=1.245 as=0.0441 ps=0.63 w=0.42 l=0.15
X10 a_561_463# a_206_368# a_454_503# VPB sky130_fd_pr__pfet_01v8 ad=0.09835 pd=1.005 as=0.09835 ps=1.005 w=0.42 l=0.15
X11 a_206_368# a_27_74# VPWR VPB sky130_fd_pr__pfet_01v8 ad=0.3304 pd=2.83 as=0.168 ps=1.42 w=1.12 l=0.15
X12 a_1011_424# a_27_74# a_713_458# VPB sky130_fd_pr__pfet_01v8 ad=0.1428 pd=1.225 as=0.2331 ps=1.395 w=0.84 l=0.15
X13 VPWR a_1210_314# a_1118_508# VPB sky130_fd_pr__pfet_01v8 ad=0.1239 pd=1.43 as=0.09975 ps=0.895 w=0.42 l=0.15
X14 a_1168_124# a_27_74# a_1011_424# VNB sky130_fd_pr__nfet_01v8_lvt ad=0.05565 pd=0.685 as=0.1181 ps=1.035 w=0.42 l=0.15
X15 Q a_1210_314# VGND VNB sky130_fd_pr__nfet_01v8_lvt ad=0.2109 pd=2.05 as=0.1229 ps=1.085 w=0.74 l=0.15
X16 a_713_458# a_561_463# VPWR VPB sky130_fd_pr__pfet_01v8 ad=0.2331 pd=1.395 as=0.18985 ps=1.545 w=0.84 l=0.15
X17 a_561_463# a_27_74# a_454_503# VNB sky130_fd_pr__nfet_01v8_lvt ad=0.07875 pd=0.865 as=0.15563 ps=1.215 w=0.42 l=0.15
X18 VPWR a_713_458# a_668_503# VPB sky130_fd_pr__pfet_01v8 ad=0.18985 pd=1.545 as=0.0504 ps=0.66 w=0.42 l=0.15
X19 VGND a_1011_424# a_1210_314# VNB sky130_fd_pr__nfet_01v8_lvt ad=0.1229 pd=1.085 as=0.1824 ps=1.85 w=0.64 l=0.15
X20 a_206_368# a_27_74# VGND VNB sky130_fd_pr__nfet_01v8_lvt ad=0.2553 pd=2.17 as=0.1739 ps=1.21 w=0.74 l=0.15
X21 a_731_101# a_206_368# a_561_463# VNB sky130_fd_pr__nfet_01v8_lvt ad=0.0441 pd=0.63 as=0.07875 ps=0.865 w=0.42 l=0.15
X22 a_1011_424# a_206_368# a_713_458# VNB sky130_fd_pr__nfet_01v8_lvt ad=0.1181 pd=1.035 as=0.10905 ps=1.025 w=0.55 l=0.15
X23 a_454_503# D VGND VNB sky130_fd_pr__nfet_01v8_lvt ad=0.15563 pd=1.215 as=0.23015 ps=2.1 w=0.42 l=0.15
.ends

.subckt register_array clk reset enable count.0 count.1 count.2 count.3 count.4 count.5 count.6 count.7 stored_values.0 stored_values.1 stored_values.2 stored_values.3 stored_values.4 stored_values.5 stored_values.6 stored_values.7 VGND VPWR

* Standard Cells
x__0__ stored_values.0 count.0 enable VGND VGND VPWR VPWR __21__ sky130_fd_sc_hs_ra__mux2i_1
x__1__ reset __21__ VGND VGND VPWR VPWR __22__ sky130_fd_sc_hs_ra__nor2_1
x__2__ stored_values.1 count.1 enable VGND VGND VPWR VPWR __23__ sky130_fd_sc_hs_ra__mux2i_1
x__3__ reset __23__ VGND VGND VPWR VPWR __24__ sky130_fd_sc_hs_ra__nor2_1
x__4__ stored_values.2 count.2 enable VGND VGND VPWR VPWR __25__ sky130_fd_sc_hs_ra__mux2i_1
x__5__ reset __25__ VGND VGND VPWR VPWR __26__ sky130_fd_sc_hs_ra__nor2_1
x__6__ stored_values.3 count.3 enable VGND VGND VPWR VPWR __27__ sky130_fd_sc_hs_ra__mux2i_1
x__7__ reset __27__ VGND VGND VPWR VPWR __28__ sky130_fd_sc_hs_ra__nor2_1
x__8__ stored_values.4 count.4 enable VGND VGND VPWR VPWR __29__ sky130_fd_sc_hs_ra__mux2i_1
x__9__ reset __29__ VGND VGND VPWR VPWR __30__ sky130_fd_sc_hs_ra__nor2_1
x__10__ stored_values.5 count.5 enable VGND VGND VPWR VPWR __31__ sky130_fd_sc_hs_ra__mux2i_1
x__11__ reset __31__ VGND VGND VPWR VPWR __32__ sky130_fd_sc_hs_ra__nor2_1
x__12__ stored_values.6 count.6 enable VGND VGND VPWR VPWR __33__ sky130_fd_sc_hs_ra__mux2i_1
x__13__ reset __33__ VGND VGND VPWR VPWR __34__ sky130_fd_sc_hs_ra__nor2_1
x__14__ stored_values.7 count.7 enable VGND VGND VPWR VPWR __35__ sky130_fd_sc_hs_ra__mux2i_1
x__15__ reset __35__ VGND VGND VPWR VPWR __36__ sky130_fd_sc_hs_ra__nor2_1
x__16__ clk __22__ VGND VGND VPWR VPWR stored_values.0 sky130_fd_sc_hs_ra__dfxtp_1
x__17__ clk __24__ VGND VGND VPWR VPWR stored_values.1 sky130_fd_sc_hs_ra__dfxtp_1
x__18__ clk __26__ VGND VGND VPWR VPWR stored_values.2 sky130_fd_sc_hs_ra__dfxtp_1
x__19__ clk __28__ VGND VGND VPWR VPWR stored_values.3 sky130_fd_sc_hs_ra__dfxtp_1
x__20__ clk __30__ VGND VGND VPWR VPWR stored_values.4 sky130_fd_sc_hs_ra__dfxtp_1
x__21__ clk __32__ VGND VGND VPWR VPWR stored_values.5 sky130_fd_sc_hs_ra__dfxtp_1
x__22__ clk __34__ VGND VGND VPWR VPWR stored_values.6 sky130_fd_sc_hs_ra__dfxtp_1
x__23__ clk __36__ VGND VGND VPWR VPWR stored_values.7 sky130_fd_sc_hs_ra__dfxtp_1

.ends
