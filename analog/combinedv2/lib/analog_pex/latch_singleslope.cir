* latch_singleslope w/ parasitics
.subckt latch_singleslope vdd ck outp outn in1 in2 vss
    X0 a_21260_4437.t9 in1.t0 a_21240_n344.t11 vss.t24 sky130_fd_pr__nfet_01v8 ad=0p pd=0u as=0p ps=0u w=1.1e+07u l=900000u
    X1 a_21248_2202.t12 a_21306_2176.t13 vdd.t23 vdd.t22 sky130_fd_pr__pfet_01v8 ad=0p pd=0u as=0p ps=0u w=9e+06u l=900000u
    X2 vdd.t3 ck.t0 a_21260_4437.t0 vdd.t2 sky130_fd_pr__pfet_01v8 ad=0p pd=0u as=0p ps=0u w=1e+06u l=150000u
    X3 vdd.t5 a_21248_2202.t13 a_21306_2176.t2 vdd.t4 sky130_fd_pr__pfet_01v8 ad=0p pd=0u as=0p ps=0u w=9e+06u l=900000u
    X4 vss.t3 a_21306_2176.t14 outn.t0 vss.t2 sky130_fd_pr__nfet_01v8 ad=0p pd=0u as=0p ps=0u w=500000u l=150000u
    X5 a_22430_n344.t8 in2.t0 a_21240_n344.t15 vss.t30 sky130_fd_pr__nfet_01v8 ad=0p pd=0u as=0p ps=0u w=1.1e+07u l=900000u
    X6 a_21240_n344.t13 in1.t1 a_21260_4437.t8 vss.t23 sky130_fd_pr__nfet_01v8 ad=0p pd=0u as=0p ps=0u w=1.1e+07u l=900000u
    X7 a_21248_2202.t8 a_21306_2176.t15 a_21260_4437.t16 vss.t39 sky130_fd_pr__nfet_01v8 ad=0p pd=0u as=0p ps=0u w=9e+06u l=900000u
    X8 a_22430_n344.t16 a_21248_2202.t14 a_21306_2176.t1 vss.t10 sky130_fd_pr__nfet_01v8 ad=0p pd=0u as=0p ps=0u w=9e+06u l=900000u
    X9 a_22430_n344.t15 a_21248_2202.t15 a_21306_2176.t0 vss.t6 sky130_fd_pr__nfet_01v8 ad=0p pd=0u as=0p ps=0u w=9e+06u l=900000u
    X10 vdd.t21 a_21306_2176.t16 a_21248_2202.t11 vdd.t20 sky130_fd_pr__pfet_01v8 ad=0p pd=0u as=0p ps=0u w=9e+06u l=900000u
    X11 a_21240_n344.t18 a_21060_n370# a_21002_n344.t0 vss.t36 sky130_fd_pr__nfet_01v8 ad=0p pd=0u as=0p ps=0u w=1.1e+07u l=900000u
    X12 a_21260_4437.t7 in1.t2 a_21240_n344.t8 vss.t22 sky130_fd_pr__nfet_01v8 ad=0p pd=0u as=0p ps=0u w=1.1e+07u l=900000u
    X13 a_21306_2176.t4 a_21248_2202.t16 a_22430_n344.t14 vss.t12 sky130_fd_pr__nfet_01v8 ad=0p pd=0u as=0p ps=0u w=9e+06u l=900000u
    X14 a_22430_n344.t7 in2.t1 a_21240_n344.t3 vss.t8 sky130_fd_pr__nfet_01v8 ad=0p pd=0u as=0p ps=0u w=1.1e+07u l=900000u
    X15 a_21248_2202.t7 a_21306_2176.t17 a_21260_4437.t11 vss.t26 sky130_fd_pr__nfet_01v8 ad=0p pd=0u as=0p ps=0u w=9e+06u l=900000u
    X16 a_21260_4437.t13 a_21306_2176.t18 a_21248_2202.t6 vss.t35 sky130_fd_pr__nfet_01v8 ad=0p pd=0u as=0p ps=0u w=9e+06u l=900000u
    X17 a_22430_n344.t13 a_21248_2202.t17 a_21306_2176.t7 vss.t28 sky130_fd_pr__nfet_01v8 ad=0p pd=0u as=0p ps=0u w=9e+06u l=900000u
    X18 a_21306_2176.t9 a_21248_2202.t18 a_22430_n344.t12 vss.t33 sky130_fd_pr__nfet_01v8 ad=0p pd=0u as=0p ps=0u w=9e+06u l=900000u
    X19 a_21240_n344.t10 in1.t3 a_21260_4437.t6 vss.t21 sky130_fd_pr__nfet_01v8 ad=0p pd=0u as=0p ps=0u w=1.1e+07u l=900000u
    X20 a_21260_4437.t5 in1.t4 a_21240_n344.t12 vss.t20 sky130_fd_pr__nfet_01v8 ad=0p pd=0u as=0p ps=0u w=1.1e+07u l=900000u
    X21 a_21306_2176.t11 a_21248_2202.t19 vdd.t14 vdd.t13 sky130_fd_pr__pfet_01v8 ad=0p pd=0u as=0p ps=0u w=9e+06u l=900000u
    X22 vdd.t19 a_21306_2176.t19 outn.t1 vdd.t6 sky130_fd_pr__pfet_01v8 ad=0p pd=0u as=0p ps=0u w=1e+06u l=150000u
    X23 a_22430_n344.t0 ck.t1 vdd.t1 vdd.t0 sky130_fd_pr__pfet_01v8 ad=0p pd=0u as=0p ps=0u w=1e+06u l=150000u
    X24 a_21260_4437.t1 a_21306_2176.t20 a_21248_2202.t5 vss.t15 sky130_fd_pr__nfet_01v8 ad=0p pd=0u as=0p ps=0u w=9e+06u l=900000u
    X25 a_21306_2176.t8 a_21248_2202.t20 a_22430_n344.t11 vss.t29 sky130_fd_pr__nfet_01v8 ad=0p pd=0u as=0p ps=0u w=9e+06u l=900000u
    X26 a_21240_n344.t1 in2.t2 a_22430_n344.t6 vss.t1 sky130_fd_pr__nfet_01v8 ad=0p pd=0u as=0p ps=0u w=1.1e+07u l=900000u
    X27 outp.t0 a_21248_2202.t21 vss.t5 vss.t4 sky130_fd_pr__nfet_01v8 ad=0p pd=0u as=0p ps=0u w=500000u l=150000u
    X28 a_21248_2202.t0 ck.t2 vdd.t10 vdd.t9 sky130_fd_pr__pfet_01v8 ad=0p pd=0u as=0p ps=0u w=1e+06u l=150000u
    X29 vdd.t12 a_21248_2202.t22 a_21306_2176.t10 vdd.t11 sky130_fd_pr__pfet_01v8 ad=0p pd=0u as=0p ps=0u w=9e+06u l=900000u
    X30 a_21248_2202.t4 a_21306_2176.t21 a_21260_4437.t12 vss.t34 sky130_fd_pr__nfet_01v8 ad=0p pd=0u as=0p ps=0u w=9e+06u l=900000u
    X31 a_21306_2176.t5 a_21248_2202.t23 a_22430_n344.t10 vss.t16 sky130_fd_pr__nfet_01v8 ad=0p pd=0u as=0p ps=0u w=9e+06u l=900000u
    X32 a_21240_n344.t2 in2.t3 a_22430_n344.t5 vss.t7 sky130_fd_pr__nfet_01v8 ad=0p pd=0u as=0p ps=0u w=1.1e+07u l=900000u
    X33 vdd.t18 a_21306_2176.t22 a_21248_2202.t10 vdd.t17 sky130_fd_pr__pfet_01v8 ad=0p pd=0u as=0p ps=0u w=9e+06u l=900000u
    X34 a_21248_2202.t3 a_21306_2176.t23 a_21260_4437.t14 vss.t37 sky130_fd_pr__nfet_01v8 ad=0p pd=0u as=0p ps=0u w=9e+06u l=900000u
    X35 a_21306_2176.t12 a_21248_2202.t24 vdd.t25 vdd.t24 sky130_fd_pr__pfet_01v8 ad=0p pd=0u as=0p ps=0u w=9e+06u l=900000u
    X36 a_21260_4437.t15 a_21306_2176.t24 a_21248_2202.t2 vss.t38 sky130_fd_pr__nfet_01v8 ad=0p pd=0u as=0p ps=0u w=9e+06u l=900000u
    X37 a_22430_n344.t9 a_21248_2202.t25 a_21306_2176.t6 vss.t27 sky130_fd_pr__nfet_01v8 ad=0p pd=0u as=0p ps=0u w=9e+06u l=900000u
    X38 a_21260_4437.t4 in1.t5 a_21240_n344.t9 vss.t19 sky130_fd_pr__nfet_01v8 ad=0p pd=0u as=0p ps=0u w=1.1e+07u l=900000u
    X39 a_21240_n344.t17 in2.t4 a_22430_n344.t4 vss.t32 sky130_fd_pr__nfet_01v8 ad=0p pd=0u as=0p ps=0u w=1.1e+07u l=900000u
    X40 a_21240_n344.t14 in1.t6 a_21260_4437.t3 vss.t18 sky130_fd_pr__nfet_01v8 ad=0p pd=0u as=0p ps=0u w=1.1e+07u l=900000u
    X41 a_22430_n344.t3 in2.t5 a_21240_n344.t0 vss.t0 sky130_fd_pr__nfet_01v8 ad=0p pd=0u as=0p ps=0u w=1.1e+07u l=900000u
    X42 a_25286_n344.t0 a_25106_n370# a_21240_n344.t5 vss.t11 sky130_fd_pr__nfet_01v8 ad=0p pd=0u as=0p ps=0u w=1.1e+07u l=900000u
    X43 vdd.t7 ck.t3 a_21306_2176.t3 vdd.t6 sky130_fd_pr__pfet_01v8 ad=0p pd=0u as=0p ps=0u w=1e+06u l=150000u
    X44 a_21248_2202.t9 a_21306_2176.t25 vdd.t16 vdd.t15 sky130_fd_pr__pfet_01v8 ad=0p pd=0u as=0p ps=0u w=9e+06u l=900000u
    X45 outp.t1 a_21248_2202.t26 vdd.t8 vdd.t0 sky130_fd_pr__pfet_01v8 ad=0p pd=0u as=0p ps=0u w=1e+06u l=150000u
    X46 vss.t14 ck.t4 a_21240_n344.t6 vss.t13 sky130_fd_pr__nfet_01v8 ad=0p pd=0u as=0p ps=0u w=4e+06u l=900000u
    X47 a_21260_4437.t10 a_21306_2176.t26 a_21248_2202.t1 vss.t25 sky130_fd_pr__nfet_01v8 ad=0p pd=0u as=0p ps=0u w=9e+06u l=900000u
    X48 a_21240_n344.t16 in2.t6 a_22430_n344.t2 vss.t31 sky130_fd_pr__nfet_01v8 ad=0p pd=0u as=0p ps=0u w=1.1e+07u l=900000u
    X49 a_22430_n344.t1 in2.t7 a_21240_n344.t4 vss.t9 sky130_fd_pr__nfet_01v8 ad=0p pd=0u as=0p ps=0u w=1.1e+07u l=900000u
    X50 a_21240_n344.t7 in1.t7 a_21260_4437.t2 vss.t17 sky130_fd_pr__nfet_01v8 ad=0p pd=0u as=0p ps=0u w=1.1e+07u l=900000u
    R0 in1.n4 in1.t5 372.779
    R1 in1.n0 in1.t7 372.779
    R2 in1.n4 in1.t3 309.312
    R3 in1.n5 in1.t2 309.312
    R4 in1.n0 in1.t4 309.312
    R5 in1.n1 in1.t6 309.312
    R6 in1.n6 in1.t1 294.585
    R7 in1.n2 in1.t0 294.585
    R8 in1.n5 in1.n4 63.466
    R9 in1.n1 in1.n0 63.466
    R10 in1.n2 in1.n1 58.619
    R11 in1.n6 in1.n5 58.469
    R12 in1.n3 in1.n2 4.965
    R13 in1 in1.n6 4.568
    R14 in1.n7 in1.n3 3.763
    R15 in1.n3 in1 1.376
    R16 in1.n7 in1 0.157
    R17 in1.n7 in1 0.049
    R18 a_21240_n344.n0 a_21240_n344.t6 12.765
    R19 a_21240_n344.n11 a_21240_n344.n10 2.344
    R20 a_21240_n344.n3 a_21240_n344.n2 2.334
    R21 a_21240_n344.n12 a_21240_n344.n8 2.032
    R22 a_21240_n344.n11 a_21240_n344.n9 2.025
    R23 a_21240_n344.n15 a_21240_n344.n14 2.013
    R24 a_21240_n344.n13 a_21240_n344.n7 2.012
    R25 a_21240_n344.n3 a_21240_n344.n0 2.01
    R26 a_21240_n344.n4 a_21240_n344.n1 2.008
    R27 a_21240_n344.n6 a_21240_n344.n5 2.008
    R28 a_21240_n344.n0 a_21240_n344.t14 1.582
    R29 a_21240_n344.n2 a_21240_n344.t5 1.581
    R30 a_21240_n344.n2 a_21240_n344.t7 1.581
    R31 a_21240_n344.n1 a_21240_n344.t11 1.581
    R32 a_21240_n344.n1 a_21240_n344.t17 1.581
    R33 a_21240_n344.n5 a_21240_n344.t3 1.581
    R34 a_21240_n344.n5 a_21240_n344.t2 1.581
    R35 a_21240_n344.n7 a_21240_n344.t15 1.581
    R36 a_21240_n344.n7 a_21240_n344.t1 1.581
    R37 a_21240_n344.n8 a_21240_n344.t4 1.581
    R38 a_21240_n344.n8 a_21240_n344.t13 1.581
    R39 a_21240_n344.n9 a_21240_n344.t8 1.581
    R40 a_21240_n344.n9 a_21240_n344.t10 1.581
    R41 a_21240_n344.n10 a_21240_n344.t9 1.581
    R42 a_21240_n344.n10 a_21240_n344.t18 1.581
    R43 a_21240_n344.n0 a_21240_n344.t12 1.581
    R44 a_21240_n344.t0 a_21240_n344.n15 1.581
    R45 a_21240_n344.n15 a_21240_n344.t16 1.581
    R46 a_21240_n344.n6 a_21240_n344.n4 0.326
    R47 a_21240_n344.n4 a_21240_n344.n3 0.325
    R48 a_21240_n344.n14 a_21240_n344.n6 0.324
    R49 a_21240_n344.n14 a_21240_n344.n13 0.324
    R50 a_21240_n344.n12 a_21240_n344.n11 0.323
    R51 a_21240_n344.n13 a_21240_n344.n12 0.322
    R52 a_21260_4437.n0 a_21260_4437.t0 36.692
    R53 a_21260_4437.n12 a_21260_4437.n11 2.699
    R54 a_21260_4437.n5 a_21260_4437.t11 1.933
    R55 a_21260_4437.n5 a_21260_4437.t1 1.933
    R56 a_21260_4437.n2 a_21260_4437.t16 1.933
    R57 a_21260_4437.n2 a_21260_4437.t13 1.933
    R58 a_21260_4437.n3 a_21260_4437.t14 1.933
    R59 a_21260_4437.n3 a_21260_4437.t10 1.933
    R60 a_21260_4437.n0 a_21260_4437.t12 1.933
    R61 a_21260_4437.n0 a_21260_4437.t15 1.933
    R62 a_21260_4437.n1 a_21260_4437.t2 1.581
    R63 a_21260_4437.n1 a_21260_4437.t5 1.581
    R64 a_21260_4437.n8 a_21260_4437.t6 1.581
    R65 a_21260_4437.n8 a_21260_4437.t4 1.581
    R66 a_21260_4437.n10 a_21260_4437.t8 1.581
    R67 a_21260_4437.n10 a_21260_4437.t7 1.581
    R68 a_21260_4437.n13 a_21260_4437.t3 1.581
    R69 a_21260_4437.t9 a_21260_4437.n13 1.581
    R70 a_21260_4437.n4 a_21260_4437.n2 1.354
    R71 a_21260_4437.n12 a_21260_4437.n1 1.281
    R72 a_21260_4437.n9 a_21260_4437.n7 1.188
    R73 a_21260_4437.n7 a_21260_4437.n0 1.146
    R74 a_21260_4437.n9 a_21260_4437.n8 1.043
    R75 a_21260_4437.n6 a_21260_4437.n5 0.97
    R76 a_21260_4437.n4 a_21260_4437.n3 0.965
    R77 a_21260_4437.n13 a_21260_4437.n12 0.879
    R78 a_21260_4437.n11 a_21260_4437.n10 0.87
    R79 a_21260_4437.n6 a_21260_4437.n4 0.373
    R80 a_21260_4437.n11 a_21260_4437.n9 0.213
    R81 a_21260_4437.n7 a_21260_4437.n6 0.199
    R82 vss.n59 vss.n54 5846.26
    R83 vss.n59 vss.n55 5846.26
    R84 vss.n7 vss.n6 419.654
    R85 vss.n24 vss.t4 406.153
    R86 vss.n24 vss.t2 406.153
    R87 vss.n58 vss.n56 379.858
    R88 vss.n58 vss.n57 379.858
    R89 vss.t36 vss.n1 356.219
    R90 vss.t20 vss.t28 220.748
    R91 vss.t33 vss.t32 220.748
    R92 vss.t7 vss.t16 220.748
    R93 vss.n60 vss.t27 217.942
    R94 vss.n45 vss.n14 216.306
    R95 vss.n12 vss.t11 216.071
    R96 vss.t31 vss.t35 215.136
    R97 vss.t30 vss.t37 215.136
    R98 vss.t34 vss.t22 215.136
    R99 vss.t38 vss.t21 215.136
    R100 vss.n31 vss.n30 213.457
    R101 vss.n7 vss.t19 210.459
    R102 vss.t13 vss.t18 188.945
    R103 vss.t6 vss.n40 111.309
    R104 vss.n64 vss.t0 111.309
    R105 vss.n4 vss.t26 111.309
    R106 vss.n40 vss.t24 109.438
    R107 vss.n64 vss.t39 103.826
    R108 vss.n4 vss.t9 103.826
    R109 vss.n28 vss.n16 94.555
    R110 vss.n20 vss.n19 93.363
    R111 vss.n17 vss.t5 39.6
    R112 vss.n17 vss.t3 39.6
    R113 vss vss.n65 31.958
    R114 vss.t13 vss.t29 31.802
    R115 vss.n7 vss.t36 12.159
    R116 vss.n21 vss.n20 9.513
    R117 vss.n32 vss.n31 9.3
    R118 vss.n48 vss.n47 9.3
    R119 vss.n52 vss.n51 9.3
    R120 vss.t39 vss.t31 7.482
    R121 vss.t35 vss.t30 7.482
    R122 vss.t37 vss.t1 7.482
    R123 vss.t9 vss.t25 7.482
    R124 vss.t26 vss.t23 7.482
    R125 vss.t22 vss.t15 7.482
    R126 vss.t21 vss.t34 7.482
    R127 vss.t19 vss.t38 7.482
    R128 vss.n46 vss.t14 4.815
    R129 vss.n27 vss.n26 3.913
    R130 vss.n44 vss.n43 3.359
    R131 vss.n52 vss.n50 3.268
    R132 vss.n9 vss.n8 3.259
    R133 vss.t0 vss.n60 2.806
    R134 vss.n65 vss.n52 2.527
    R135 vss.n64 vss.n53 2.469
    R136 vss.n12 vss.n11 1.876
    R137 vss.t11 vss.t12 1.87
    R138 vss.t28 vss.t17 1.87
    R139 vss.t29 vss.t20 1.87
    R140 vss.t18 vss.t6 1.87
    R141 vss.t24 vss.t33 1.87
    R142 vss.t32 vss.t10 1.87
    R143 vss.t16 vss.t8 1.87
    R144 vss.t27 vss.t7 1.87
    R145 vss.n48 vss.n46 1.506
    R146 vss.n49 vss.n48 1.393
    R147 vss.n50 vss.n49 1.346
    R148 vss.n8 vss.n7 1.196
    R149 vss.n32 vss.n28 1.033
    R150 vss.n46 vss.n45 0.903
    R151 vss.n21 vss.n17 0.728
    R152 vss.n66 vss 0.395
    R153 vss.n44 vss.n32 0.306
    R154 vss.n45 vss.n44 0.263
    R155 vss.n28 vss.n27 0.243
    R156 vss.n53 vss.n9 0.133
    R157 vss.n26 vss.n25 0.116
    R158 vss.n25 vss.n24 0.116
    R159 vss.n43 vss.n42 0.097
    R160 vss.n42 vss.n41 0.081
    R161 vss.n27 vss.n21 0.072
    R162 vss.n19 vss.n18 0.061
    R163 vss.n16 vss.n15 0.061
    R164 vss.n23 vss.n22 0.059
    R165 vss.n24 vss.n23 0.059
    R166 vss.n34 vss.n33 0.049
    R167 vss.n66 vss.n9 0.047
    R168 vss.n35 vss.n34 0.041
    R169 vss.n41 vss.t13 0.017
    R170 vss.n30 vss.n29 0.016
    R171 vss.n14 vss.n13 0.016
    R172 vss.t13 vss.n35 0.009
    R173 vss.n59 vss.n58 0.007
    R174 vss.n60 vss.n59 0.007
    R175 vss.n6 vss.n5 0.007
    R176 vss.n37 vss.n36 0.007
    R177 vss.n40 vss.n37 0.007
    R178 vss.n3 vss.n2 0.007
    R179 vss.n4 vss.n3 0.007
    R180 vss.n5 vss.n4 0.007
    R181 vss.n39 vss.n38 0.007
    R182 vss.n40 vss.n39 0.007
    R183 vss.n1 vss.n0 0.006
    R184 vss.n11 vss.n10 0.006
    R185 vss.n62 vss.n61 0.003
    R186 vss.n65 vss.n64 0.002
    R187 vss.n64 vss.n63 0.002
    R188 vss.n63 vss.n62 0.002
    R189 vss.n49 vss.n12 0.001
    R190 a_21306_2176.n11 a_21306_2176.t24 315.781
    R191 a_21306_2176.n4 a_21306_2176.t25 315.654
    R192 a_21306_2176.n5 a_21306_2176.t13 308.736
    R193 a_21306_2176.n4 a_21306_2176.t22 258.003
    R194 a_21306_2176.n16 a_21306_2176.t18 255.758
    R195 a_21306_2176.n15 a_21306_2176.t23 255.758
    R196 a_21306_2176.n14 a_21306_2176.t26 255.758
    R197 a_21306_2176.n13 a_21306_2176.t17 255.758
    R198 a_21306_2176.n12 a_21306_2176.t20 255.758
    R199 a_21306_2176.n11 a_21306_2176.t21 255.758
    R200 a_21306_2176.n8 a_21306_2176.t19 246.022
    R201 a_21306_2176.n5 a_21306_2176.t16 241.03
    R202 a_21306_2176.n17 a_21306_2176.t15 241.029
    R203 a_21306_2176.n8 a_21306_2176.t14 151.882
    R204 a_21306_2176.n12 a_21306_2176.n11 60.024
    R205 a_21306_2176.n13 a_21306_2176.n12 60.024
    R206 a_21306_2176.n14 a_21306_2176.n13 60.024
    R207 a_21306_2176.n15 a_21306_2176.n14 60.024
    R208 a_21306_2176.n16 a_21306_2176.n15 60.024
    R209 a_21306_2176.n17 a_21306_2176.n16 57.906
    R210 a_21306_2176.n10 a_21306_2176.t3 33.488
    R211 a_21306_2176.n6 a_21306_2176.n4 10.112
    R212 a_21306_2176.n18 a_21306_2176.n17 9.645
    R213 a_21306_2176.n6 a_21306_2176.n5 5.964
    R214 a_21306_2176.n0 a_21306_2176.t2 3.173
    R215 a_21306_2176.n0 a_21306_2176.t11 3.173
    R216 a_21306_2176.n3 a_21306_2176.t10 3.173
    R217 a_21306_2176.n3 a_21306_2176.t12 3.173
    R218 a_21306_2176.n2 a_21306_2176.t4 3.164
    R219 a_21306_2176.n10 a_21306_2176.n0 3.034
    R220 a_21306_2176.n7 a_21306_2176.n6 2.855
    R221 a_21306_2176.n18 a_21306_2176.t6 2.583
    R222 a_21306_2176.n20 a_21306_2176.t1 1.933
    R223 a_21306_2176.n20 a_21306_2176.t5 1.933
    R224 a_21306_2176.n1 a_21306_2176.t7 1.933
    R225 a_21306_2176.n1 a_21306_2176.t8 1.933
    R226 a_21306_2176.t0 a_21306_2176.n23 1.933
    R227 a_21306_2176.n23 a_21306_2176.t9 1.933
    R228 a_21306_2176.n9 a_21306_2176.n8 1.905
    R229 a_21306_2176.n19 a_21306_2176.n10 1.831
    R230 a_21306_2176.n9 a_21306_2176.n7 0.793
    R231 a_21306_2176.n22 a_21306_2176.n2 0.712
    R232 a_21306_2176.n22 a_21306_2176.n21 0.676
    R233 a_21306_2176.n23 a_21306_2176.n22 0.63
    R234 a_21306_2176.n21 a_21306_2176.n20 0.627
    R235 a_21306_2176.n2 a_21306_2176.n1 0.614
    R236 a_21306_2176.n7 a_21306_2176.n3 0.483
    R237 a_21306_2176.n0 a_21306_2176.n9 0.47
    R238 a_21306_2176.n21 a_21306_2176.n19 0.465
    R239 a_21306_2176.n19 a_21306_2176.n18 0.204
    R240 vdd.n28 vdd.n21 741.176
    R241 vdd.n28 vdd.n22 741.176
    R242 vdd.n33 vdd.n6 415.752
    R243 vdd.n60 vdd.n59 410.636
    R244 vdd.n43 vdd.n42 119.209
    R245 vdd.n49 vdd.n48 110.689
    R246 vdd.t15 vdd.t17 100.533
    R247 vdd.t4 vdd.t15 100.533
    R248 vdd.t13 vdd.t4 100.533
    R249 vdd.t24 vdd.t11 100.533
    R250 vdd.t20 vdd.t24 100.533
    R251 vdd.t22 vdd.t20 100.533
    R252 vdd.n62 vdd.t22 98.421
    R253 vdd.n13 vdd.n10 93.741
    R254 vdd.n13 vdd.n12 93.741
    R255 vdd.n20 vdd.n17 93.741
    R256 vdd.n20 vdd.n19 93.741
    R257 vdd.n29 vdd.n20 76.318
    R258 vdd.n37 vdd.t9 71.473
    R259 vdd.n37 vdd.t2 71.473
    R260 vdd.n3 vdd.t13 50.266
    R261 vdd.n27 vdd.t0 38.974
    R262 vdd.n27 vdd.t6 38.974
    R263 vdd.n31 vdd.n13 37.08
    R264 vdd.n7 vdd.t1 32.505
    R265 vdd.n7 vdd.t7 32.505
    R266 vdd.n40 vdd.t10 32.505
    R267 vdd.n40 vdd.t3 32.505
    R268 vdd.n14 vdd.t8 32.505
    R269 vdd.n14 vdd.t19 32.505
    R270 vdd vdd.n62 21.542
    R271 vdd.n44 vdd.n43 9.456
    R272 vdd.n59 vdd.n58 9.3
    R273 vdd.n52 vdd.t18 5.809
    R274 vdd.n55 vdd.t23 5.787
    R275 vdd.n57 vdd.n56 4.621
    R276 vdd.n54 vdd.t25 3.173
    R277 vdd.n54 vdd.t21 3.173
    R278 vdd.n51 vdd.t16 3.173
    R279 vdd.n51 vdd.t5 3.173
    R280 vdd.n50 vdd.t14 3.173
    R281 vdd.n50 vdd.t12 3.173
    R282 vdd.n53 vdd.n50 1.86
    R283 vdd.n55 vdd.n54 1.858
    R284 vdd.n52 vdd.n51 1.856
    R285 vdd.n58 vdd.n34 1.527
    R286 vdd.n34 vdd.n33 1.482
    R287 vdd.n32 vdd.n31 0.929
    R288 vdd.n30 vdd.n14 0.922
    R289 vdd.n32 vdd.n7 0.904
    R290 vdd.n58 vdd.n57 0.843
    R291 vdd.n44 vdd.n40 0.831
    R292 vdd.n56 vdd.n55 0.77
    R293 vdd.n53 vdd.n52 0.769
    R294 vdd.n33 vdd.n32 0.422
    R295 vdd.n49 vdd.n45 0.226
    R296 vdd.n31 vdd.n30 0.225
    R297 vdd.n57 vdd.n49 0.136
    R298 vdd.n45 vdd.n44 0.045
    R299 vdd.n36 vdd.n35 0.019
    R300 vdd.n37 vdd.n36 0.019
    R301 vdd.n26 vdd.n25 0.019
    R302 vdd.n27 vdd.n26 0.019
    R303 vdd.n24 vdd.n23 0.019
    R304 vdd.n27 vdd.n24 0.019
    R305 vdd.n42 vdd.n41 0.013
    R306 vdd.n48 vdd.n47 0.013
    R307 vdd.n47 vdd.n46 0.013
    R308 vdd.n17 vdd.n16 0.013
    R309 vdd.n16 vdd.n15 0.013
    R310 vdd.n12 vdd.n11 0.013
    R311 vdd.n19 vdd.n18 0.013
    R312 vdd.n10 vdd.n9 0.013
    R313 vdd.n9 vdd.n8 0.013
    R314 vdd.n56 vdd.n53 0.002
    R315 vdd.n61 vdd.n60 0.002
    R316 vdd.n62 vdd.n61 0.002
    R317 vdd.n6 vdd.n5 0.002
    R318 vdd.n5 vdd.n4 0.002
    R319 vdd.n1 vdd.n0 0.002
    R320 vdd.n2 vdd.n1 0.002
    R321 vdd.n3 vdd.n2 0.002
    R322 vdd.n45 vdd.n39 0.001
    R323 vdd.n30 vdd.n29 0.001
    R324 vdd.n39 vdd.n38 0.001
    R325 vdd.n38 vdd.n37 0.001
    R326 vdd.n29 vdd.n28 0.001
    R327 vdd.n28 vdd.n27 0.001
    R328 vdd.n34 vdd.n3 0.001
    R329 a_21248_2202.n3 a_21248_2202.t16 320.917
    R330 a_21248_2202.n25 a_21248_2202.t24 315.647
    R331 a_21248_2202.n25 a_21248_2202.t22 258.168
    R332 a_21248_2202.n26 a_21248_2202.t19 258.168
    R333 a_21248_2202.n8 a_21248_2202.t23 255.758
    R334 a_21248_2202.n7 a_21248_2202.t14 255.758
    R335 a_21248_2202.n6 a_21248_2202.t18 255.758
    R336 a_21248_2202.n5 a_21248_2202.t15 255.758
    R337 a_21248_2202.n4 a_21248_2202.t20 255.758
    R338 a_21248_2202.n3 a_21248_2202.t17 255.758
    R339 a_21248_2202.n9 a_21248_2202.t25 241.044
    R340 a_21248_2202.n27 a_21248_2202.t13 241.028
    R341 a_21248_2202.n12 a_21248_2202.t26 228.904
    R342 a_21248_2202.n19 a_21248_2202.t21 134.5
    R343 a_21248_2202.n4 a_21248_2202.n3 65.159
    R344 a_21248_2202.n5 a_21248_2202.n4 65.159
    R345 a_21248_2202.n6 a_21248_2202.n5 65.159
    R346 a_21248_2202.n7 a_21248_2202.n6 65.159
    R347 a_21248_2202.n8 a_21248_2202.n7 65.159
    R348 a_21248_2202.n9 a_21248_2202.n8 64.943
    R349 a_21248_2202.n26 a_21248_2202.n25 57.479
    R350 a_21248_2202.n27 a_21248_2202.n26 55.831
    R351 a_21248_2202.n28 a_21248_2202.t0 33.756
    R352 a_21248_2202.n36 a_21248_2202.n9 13.281
    R353 a_21248_2202.n1 a_21248_2202.n27 10.765
    R354 a_21248_2202.n21 a_21248_2202.n20 9.3
    R355 a_21248_2202.n14 a_21248_2202.n13 9.3
    R356 a_21248_2202.n20 a_21248_2202.n19 7.136
    R357 a_21248_2202.n13 a_21248_2202.n12 6.747
    R358 a_21248_2202.n18 a_21248_2202.n17 4.16
    R359 a_21248_2202.n2 a_21248_2202.n1 3.41
    R360 a_21248_2202.n30 a_21248_2202.t2 3.38
    R361 a_21248_2202.n2 a_21248_2202.t11 3.173
    R362 a_21248_2202.n2 a_21248_2202.t12 3.173
    R363 a_21248_2202.n24 a_21248_2202.t10 3.173
    R364 a_21248_2202.n24 a_21248_2202.t9 3.173
    R365 a_21248_2202.n11 a_21248_2202.n10 3.047
    R366 a_21248_2202.n15 a_21248_2202.n14 2.303
    R367 a_21248_2202.n16 a_21248_2202.n15 2.275
    R368 a_21248_2202.n1 a_21248_2202.n23 2.209
    R369 a_21248_2202.n31 a_21248_2202.n28 1.964
    R370 a_21248_2202.t8 a_21248_2202.n36 1.934
    R371 a_21248_2202.n34 a_21248_2202.t6 1.933
    R372 a_21248_2202.n34 a_21248_2202.t3 1.933
    R373 a_21248_2202.n32 a_21248_2202.t1 1.933
    R374 a_21248_2202.n32 a_21248_2202.t7 1.933
    R375 a_21248_2202.n29 a_21248_2202.t5 1.933
    R376 a_21248_2202.n29 a_21248_2202.t4 1.933
    R377 a_21248_2202.n28 a_21248_2202.n2 1.852
    R378 a_21248_2202.n36 a_21248_2202.n35 1.425
    R379 a_21248_2202.n14 a_21248_2202.n11 0.914
    R380 a_21248_2202.n30 a_21248_2202.n29 0.808
    R381 a_21248_2202.n33 a_21248_2202.n32 0.801
    R382 a_21248_2202.n35 a_21248_2202.n34 0.8
    R383 a_21248_2202.n22 a_21248_2202.n21 0.64
    R384 a_21248_2202.n35 a_21248_2202.n33 0.632
    R385 a_21248_2202.n31 a_21248_2202.n30 0.375
    R386 a_21248_2202.n21 a_21248_2202.n18 0.32
    R387 a_21248_2202.n33 a_21248_2202.n31 0.256
    R388 a_21248_2202.n0 a_21248_2202.n16 0.065
    R389 a_21248_2202.n0 a_21248_2202.n22 4.051
    R390 a_21248_2202.n1 a_21248_2202.n24 1.147
    R391 a_21248_2202.n23 a_21248_2202.n0 0.022
    R392 ck.t2 ck.t0 562.769
    R393 ck.t1 ck.t3 558.241
    R394 ck.n4 ck.t2 242.625
    R395 ck.n0 ck.t1 241.683
    R396 ck.n0 ck.t4 123.641
    R397 ck ck.n0 5.183
    R398 ck.n6 ck.n5 1.969
    R399 ck.n7 ck.n6 0.656
    R400 ck.n5 ck.n4 0.26
    R401 ck ck.n10 0.055
    R402 ck.n2 ck.n1 0.022
    R403 ck.n3 ck.n2 0.011
    R404 ck.n10 ck.n9 0.011
    R405 ck.n8 ck.n3 0.003
    R406 ck.n9 ck.n8 0.001
    R407 ck.n8 ck.n7 0.001
    R408 outn.n0 outn.t0 39.728
    R409 outn outn.t1 32.661
    R410 outn outn.n0 0.855
    R411 outn.n1 outn 0.832
    R412 outn.n0 outn 0.471
    R413 outn outn.n1 0.467
    R414 outn.n1 outn 0.171
    R415 outn.n1 outn 0.096
    R416 in2.n5 in2.t7 374.44
    R417 in2.n0 in2.t4 374.44
    R418 in2.n2 in2.t5 313.163
    R419 in2.n6 in2.t0 309.312
    R420 in2.n5 in2.t2 309.312
    R421 in2.n1 in2.t3 309.312
    R422 in2.n0 in2.t1 309.312
    R423 in2.n3 in2.t6 309.238
    R424 in2.n6 in2.n5 65.127
    R425 in2.n1 in2.n0 65.127
    R426 in2.n2 in2.n1 49.994
    R427 in2.n7 in2.n6 45.012
    R428 in2.n8 in2.n7 9.3
    R429 in2.n4 in2.n3 7.163
    R430 in2.n4 in2.n2 2.237
    R431 in2 in2.n8 1.447
    R432 in2.n8 in2.n4 0.227
    R433 a_22430_n344.n0 a_22430_n344.t0 36.801
    R434 a_22430_n344.n1 a_22430_n344.t11 1.933
    R435 a_22430_n344.n1 a_22430_n344.t15 1.933
    R436 a_22430_n344.n2 a_22430_n344.t14 1.933
    R437 a_22430_n344.n2 a_22430_n344.t13 1.933
    R438 a_22430_n344.n5 a_22430_n344.t10 1.933
    R439 a_22430_n344.n5 a_22430_n344.t9 1.933
    R440 a_22430_n344.n0 a_22430_n344.t12 1.933
    R441 a_22430_n344.n0 a_22430_n344.t16 1.933
    R442 a_22430_n344.n11 a_22430_n344.t6 1.581
    R443 a_22430_n344.n11 a_22430_n344.t1 1.581
    R444 a_22430_n344.n9 a_22430_n344.t5 1.581
    R445 a_22430_n344.n9 a_22430_n344.t3 1.581
    R446 a_22430_n344.n7 a_22430_n344.t4 1.581
    R447 a_22430_n344.n7 a_22430_n344.t7 1.581
    R448 a_22430_n344.n13 a_22430_n344.t2 1.581
    R449 a_22430_n344.t8 a_22430_n344.n13 1.581
    R450 a_22430_n344.n3 a_22430_n344.n2 1.541
    R451 a_22430_n344.n8 a_22430_n344.n6 1.255
    R452 a_22430_n344.n12 a_22430_n344.n11 1.252
    R453 a_22430_n344.n4 a_22430_n344.n0 1.169
    R454 a_22430_n344.n6 a_22430_n344.n5 1.166
    R455 a_22430_n344.n3 a_22430_n344.n1 1.165
    R456 a_22430_n344.n8 a_22430_n344.n7 1.054
    R457 a_22430_n344.n10 a_22430_n344.n9 0.858
    R458 a_22430_n344.n13 a_22430_n344.n12 0.848
    R459 a_22430_n344.n12 a_22430_n344.n10 0.397
    R460 a_22430_n344.n4 a_22430_n344.n3 0.374
    R461 a_22430_n344.n6 a_22430_n344.n4 0.361
    R462 a_22430_n344.n10 a_22430_n344.n8 0.217
    R463 outp.n0 outp.t0 39.735
    R464 outp outp.t1 32.632
    R465 outp outp.n0 0.871
    R466 outp.n1 outp 0.816
    R467 outp.n0 outp 0.525
    R468 outp outp.n1 0.483
    R469 outp.n1 outp 0.214
    R470 outp.n1 outp 0.127
    C0 vdd outn 0.79fF
    C1 outp ck 0.01fF
    C2 vdd ck 2.39fF
    C3 in2 in1 1.53fF
    C4 a_25106_n370# in1 0.07fF
    C5 a_21060_n370# in1 0.07fF
    C6 vdd outp 0.63fF
    C7 outp outn 0.26fF
.ends
